* --- Inclusion of the Vector Fitted Model ---
.INCLUDE "cobra_output.sp"

* --- Subcircuit Call (X) ---
* Mapping nodes: p1=Port1, p2=Port2, p3=Port3, p4=Port4, p5=_net0, p6=_net1
X1 Port1 Port2 Port3 Port4 _net0 _net1 s_equivalent

* --- External Passive Components ---
C4 0 Port4  10P
C3 Port3 0  10P
C2 Port4 Port3  46.8F
C1 Port2 Port1  10.7F

* 1 Meg-Henry inductors act as high-impedance DC paths/chokes
L1 Port2 Port1  1MEG
L2 Port4 Port3  1MEG

* --- Differential Port Definitions ---
* Port 1 is between Port1 and Port2 (Z0 = 1090)
P1 Port1 Port2 port=1 z0=1090 AC 2.95296
* Port 2 is between Port3 and Port4 (Z0 = 850)
P2 Port3 Port4 port=2 z0=850  AC 2.60768

* --- Simulation Settings ---
.AC LIN 500 1G 200G
.LIN format=touchstone sparcalc=1

* --- Output ---
* .PRINT ac format=std file=spice4qucs_sparam.prn sdb(1,1) s(1,1) sdb(1,2) s(1,2) sdb(2,1) s(2,1) sdb(2,2) s(2,2)
.END
