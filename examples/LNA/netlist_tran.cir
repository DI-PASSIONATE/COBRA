* Qucs 26.1.0  /home/users/simone/Hiwi/Example_Single_LNA_COBRA.sch
.INCLUDE "/usr/local/share/qucs-s/spicelibrary/xfmr.cir"
.LIB "/home/users/simone/IHP-Open-PDK/ihp-sg13g2/libs.tech/xyce/models/cornerRES.lib" res_typ
.LIB "/home/users/simone/IHP-Open-PDK/ihp-sg13g2/libs.tech/xyce/models/cornerHBT.lib" hbt_typ
.LIB "/home/users/simone/IHP-Open-PDK/ihp-sg13g2/libs.tech/xyce/models/cornerCAP.lib" cap_typ

.SUBCKT IHP_PDK_nonlinear_components_npn13G2  gnd c b e bn Nx=1
X1 c b e bn npn13G2 Nx={Nx}
.ENDS

.SUBCKT IHP_PDK_basic_components_ptap1  gnd P1 P2 w=0.78e-6 l=0.78e-6
X1 P1 P2 ptap1 w={w} l={l}
.ENDS

.SUBCKT ideal_balun _net1 _net4 _net3 _net0 _net2
X_Tr1_W1 _net1 _net2 _net4 _net3  XFMR RATIO=0.5
X_Tr1_W2 _net1 _net2 _net0 _net4  XFMR RATIO=0.5
.ENDS

* EQUIVALENT CIRCUIT FOR VECTOR FITTED S-MATRIX
* Created using scikit-rf vectorFitting.py
*
.SUBCKT s_equivalent p1 p2 p3 p4 p5 p6
*
* Port network for port 1
V1 p1 s1 0
R1 s1 0 50.0
Gd1_1 0 s1 p1 0 3.1104811536597504e-06
Fd1_1 0 s1 V1 0.00015552405768298755
Gr1_re_1_1 0 s1 x1_re_a1 0 354525129001.0172
Gr1_im_1_1 0 s1 x1_im_a1 0 -139412700934.425
Gr2_1_1 0 s1 x2_a1 0 -887484521232.0078
Gr3_1_1 0 s1 x3_a1 0 383280531559.7347
Gr4_1_1 0 s1 x4_a1 0 -29903414949.47935
Gr5_1_1 0 s1 x5_a1 0 -243869181.99495137
Gr6_1_1 0 s1 x6_a1 0 5560148.83156236
Gd1_2 0 s1 p2 0 -4.177289486853031e-06
Fd1_2 0 s1 V2 -0.00020886447434265154
Gr1_re_1_2 0 s1 x1_re_a2 0 -194234404012.232
Gr1_im_1_2 0 s1 x1_im_a2 0 173664115136.8867
Gr2_1_2 0 s1 x2_a2 0 1698946240113.3381
Gr3_1_2 0 s1 x3_a2 0 -886557245697.0128
Gr4_1_2 0 s1 x4_a2 0 6636189190.316558
Gr5_1_2 0 s1 x5_a2 0 -682791512.5466012
Gr6_1_2 0 s1 x6_a2 0 16938989.126934987
Gd1_3 0 s1 p3 0 1.159423087961308e-05
Fd1_3 0 s1 V3 0.000579711543980654
Gr1_re_1_3 0 s1 x1_re_a3 0 109744136266.5939
Gr1_im_1_3 0 s1 x1_im_a3 0 126565895893.51207
Gr2_1_3 0 s1 x2_a3 0 -640792029470.6831
Gr3_1_3 0 s1 x3_a3 0 500827675091.5859
Gr4_1_3 0 s1 x4_a3 0 11507993377.718231
Gr5_1_3 0 s1 x5_a3 0 472502692.3000686
Gr6_1_3 0 s1 x6_a3 0 -7441359.328966653
Gd1_4 0 s1 p4 0 2.625586431598365e-06
Fd1_4 0 s1 V4 0.00013127932157991828
Gr1_re_1_4 0 s1 x1_re_a4 0 -1448176338.6687121
Gr1_im_1_4 0 s1 x1_im_a4 0 -73206456718.14374
Gr2_1_4 0 s1 x2_a4 0 130026422664.08675
Gr3_1_4 0 s1 x3_a4 0 -167894287075.4201
Gr4_1_4 0 s1 x4_a4 0 5591409948.396897
Gr5_1_4 0 s1 x5_a4 0 420292416.56200224
Gr6_1_4 0 s1 x6_a4 0 -8578298.025087308
Gd1_5 0 s1 p5 0 -1.2523134667157264e-05
Fd1_5 0 s1 V5 -0.0006261567333578633
Gr1_re_1_5 0 s1 x1_re_a5 0 -43930716668.29491
Gr1_im_1_5 0 s1 x1_im_a5 0 -158348406510.6006
Gr2_1_5 0 s1 x2_a5 0 -420406476111.18286
Gr3_1_5 0 s1 x3_a5 0 404972112889.25525
Gr4_1_5 0 s1 x4_a5 0 16819369608.469643
Gr5_1_5 0 s1 x5_a5 0 1842428707.5927064
Gr6_1_5 0 s1 x6_a5 0 -11645080.296530623
Gd1_6 0 s1 p6 0 -2.48308437022385e-05
Fd1_6 0 s1 V6 -0.0012415421851119251
Gr1_re_1_6 0 s1 x1_re_a6 0 79979986176.47168
Gr1_im_1_6 0 s1 x1_im_a6 0 172300428122.1755
Gr2_1_6 0 s1 x2_a6 0 1152933387749.9028
Gr3_1_6 0 s1 x3_a6 0 -774693588232.5602
Gr4_1_6 0 s1 x4_a6 0 -8385830425.91457
Gr5_1_6 0 s1 x5_a6 0 -1499436499.771292
Gr6_1_6 0 s1 x6_a6 0 11360542.596634375
*
* State networks driven by port 1
Cx1_re_a1 x1_re_a1 0 1.0
Gx1_re_a1 0 x1_re_a1 p1 0 0.1414213562373095
Fx1_re_a1 0 x1_re_a1 V1 7.0710678118654755
Rp1_re_re_a1 0 x1_re_a1 6.142922187756332e-13
Gp1_re_im_a1 0 x1_re_a1 x1_im_a1 0 2394667911485.9653
Cx1_im_a1 x1_im_a1 0 1.0
Gp1_im_re_a1 0 x1_im_a1 x1_re_a1 0 -2394667911485.9653
Rp1_im_im_a1 0 x1_im_a1 6.142922187756332e-13
Cx2_a1 x2_a1 0 1.0
Gx2_a1 0 x2_a1 p1 0 0.07071067811865475
Fx2_a1 0 x2_a1 V1 3.5355339059327378
Rp2_a1 0 x2_a1 6.332657793113146e-13
Cx3_a1 x3_a1 0 1.0
Gx3_a1 0 x3_a1 p1 0 0.07071067811865475
Fx3_a1 0 x3_a1 V1 3.5355339059327378
Rp3_a1 0 x3_a1 8.173123325341146e-13
Cx4_a1 x4_a1 0 1.0
Gx4_a1 0 x4_a1 p1 0 0.07071067811865475
Fx4_a1 0 x4_a1 V1 3.5355339059327378
Rp4_a1 0 x4_a1 2.0209324389001855e-12
Cx5_a1 x5_a1 0 1.0
Gx5_a1 0 x5_a1 p1 0 0.07071067811865475
Fx5_a1 0 x5_a1 V1 3.5355339059327378
Rp5_a1 0 x5_a1 8.841371352254124e-12
Cx6_a1 x6_a1 0 1.0
Gx6_a1 0 x6_a1 p1 0 0.07071067811865475
Fx6_a1 0 x6_a1 V1 3.5355339059327378
Rp6_a1 0 x6_a1 2.4045900030032587e-10
*
* Port network for port 2
V2 p2 s2 0
R2 s2 0 50.0
Gd2_1 0 s2 p1 0 -4.17728948689966e-06
Fd2_1 0 s2 V1 -0.000208864474344983
Gr1_re_2_1 0 s2 x1_re_a1 0 -194234404012.24304
Gr1_im_2_1 0 s2 x1_im_a1 0 173664115136.84314
Gr2_2_1 0 s2 x2_a1 0 1698946240113.4595
Gr3_2_1 0 s2 x3_a1 0 -886557245697.1437
Gr4_2_1 0 s2 x4_a1 0 6636189190.32431
Gr5_2_1 0 s2 x5_a1 0 -682791512.5455465
Gr6_2_1 0 s2 x6_a1 0 16938989.126878742
Gd2_2 0 s2 p2 0 1.511791357578729e-05
Fd2_2 0 s2 V2 0.0007558956787893646
Gr1_re_2_2 0 s2 x1_re_a2 0 359018291929.44867
Gr1_im_2_2 0 s2 x1_im_a2 0 -9356563763.682928
Gr2_2_2 0 s2 x2_a2 0 -308092623691.8477
Gr3_2_2 0 s2 x3_a2 0 -1282591543.8073413
Gr4_2_2 0 s2 x4_a2 0 -17879770031.719013
Gr5_2_2 0 s2 x5_a2 0 -898117599.9265025
Gr6_2_2 0 s2 x6_a2 0 11658770.453878995
Gd2_3 0 s2 p3 0 1.3176214228668125e-06
Fd2_3 0 s2 V3 6.588107114334062e-05
Gr1_re_2_3 0 s2 x1_re_a3 0 135766055.13472852
Gr1_im_2_3 0 s2 x1_im_a3 0 -89463265389.46059
Gr2_2_3 0 s2 x2_a3 0 111175364214.89967
Gr3_2_3 0 s2 x3_a3 0 -165906953047.2631
Gr4_2_3 0 s2 x4_a3 0 5642175297.373815
Gr5_2_3 0 s2 x5_a3 0 492987143.5327675
Gr6_2_3 0 s2 x6_a3 0 -9874339.18609092
Gd2_4 0 s2 p4 0 1.0680920774400088e-05
Fd2_4 0 s2 V4 0.0005340460387200045
Gr1_re_2_4 0 s2 x1_re_a4 0 118231295772.19508
Gr1_im_2_4 0 s2 x1_im_a4 0 115437438324.6237
Gr2_2_4 0 s2 x2_a4 0 -662825900523.025
Gr3_2_4 0 s2 x3_a4 0 505069558153.7508
Gr4_2_4 0 s2 x4_a4 0 11449943108.832369
Gr5_2_4 0 s2 x5_a4 0 609619647.3427258
Gr6_2_4 0 s2 x6_a4 0 -8759623.036089644
Gd2_5 0 s2 p5 0 -9.110843830093529e-06
Fd2_5 0 s2 V5 -0.00045554219150467645
Gr1_re_2_5 0 s2 x1_re_a5 0 -39220711187.71376
Gr1_im_2_5 0 s2 x1_im_a5 0 -130821680349.56897
Gr2_2_5 0 s2 x2_a5 0 -536637248430.02594
Gr3_2_5 0 s2 x3_a5 0 504846292889.32904
Gr4_2_5 0 s2 x4_a5 0 19704650380.705
Gr5_2_5 0 s2 x5_a5 0 1891928321.381517
Gr6_2_5 0 s2 x6_a5 0 -13107711.280255836
Gd2_6 0 s2 p6 0 -3.073637222989479e-05
Fd2_6 0 s2 V6 -0.0015368186114947393
Gr1_re_2_6 0 s2 x1_re_a6 0 48571149049.2406
Gr1_im_2_6 0 s2 x1_im_a6 0 133185214663.76932
Gr2_2_6 0 s2 x2_a6 0 1027797366735.4801
Gr3_2_6 0 s2 x3_a6 0 -669704761833.1664
Gr4_2_6 0 s2 x4_a6 0 -17256844762.42944
Gr5_2_6 0 s2 x5_a6 0 -1353198331.0111065
Gr6_2_6 0 s2 x6_a6 0 10907150.497566229
*
* State networks driven by port 2
Cx1_re_a2 x1_re_a2 0 1.0
Gx1_re_a2 0 x1_re_a2 p2 0 0.1414213562373095
Fx1_re_a2 0 x1_re_a2 V2 7.0710678118654755
Rp1_re_re_a2 0 x1_re_a2 6.142922187756332e-13
Gp1_re_im_a2 0 x1_re_a2 x1_im_a2 0 2394667911485.9653
Cx1_im_a2 x1_im_a2 0 1.0
Gp1_im_re_a2 0 x1_im_a2 x1_re_a2 0 -2394667911485.9653
Rp1_im_im_a2 0 x1_im_a2 6.142922187756332e-13
Cx2_a2 x2_a2 0 1.0
Gx2_a2 0 x2_a2 p2 0 0.07071067811865475
Fx2_a2 0 x2_a2 V2 3.5355339059327378
Rp2_a2 0 x2_a2 6.332657793113146e-13
Cx3_a2 x3_a2 0 1.0
Gx3_a2 0 x3_a2 p2 0 0.07071067811865475
Fx3_a2 0 x3_a2 V2 3.5355339059327378
Rp3_a2 0 x3_a2 8.173123325341146e-13
Cx4_a2 x4_a2 0 1.0
Gx4_a2 0 x4_a2 p2 0 0.07071067811865475
Fx4_a2 0 x4_a2 V2 3.5355339059327378
Rp4_a2 0 x4_a2 2.0209324389001855e-12
Cx5_a2 x5_a2 0 1.0
Gx5_a2 0 x5_a2 p2 0 0.07071067811865475
Fx5_a2 0 x5_a2 V2 3.5355339059327378
Rp5_a2 0 x5_a2 8.841371352254124e-12
Cx6_a2 x6_a2 0 1.0
Gx6_a2 0 x6_a2 p2 0 0.07071067811865475
Fx6_a2 0 x6_a2 V2 3.5355339059327378
Rp6_a2 0 x6_a2 2.4045900030032587e-10
*
* Port network for port 3
V3 p3 s3 0
R3 s3 0 50.0
Gd3_1 0 s3 p1 0 1.1594230924443158e-05
Fd3_1 0 s3 V1 0.0005797115462221579
Gr1_re_3_1 0 s3 x1_re_a1 0 109744136266.2182
Gr1_im_3_1 0 s3 x1_im_a1 0 126565895892.96973
Gr2_3_1 0 s3 x2_a1 0 -640792029472.2911
Gr3_3_1 0 s3 x3_a1 0 500827675093.01154
Gr4_3_1 0 s3 x4_a1 0 11507993377.531984
Gr5_3_1 0 s3 x5_a1 0 472502692.32050306
Gr6_3_1 0 s3 x6_a1 0 -7441359.330884014
Gd3_2 0 s3 p2 0 1.3176214532324789e-06
Fd3_2 0 s3 V2 6.588107266162395e-05
Gr1_re_3_2 0 s3 x1_re_a2 0 135766054.76920485
Gr1_im_3_2 0 s3 x1_im_a2 0 -89463265389.91989
Gr2_3_2 0 s3 x2_a2 0 111175364213.84291
Gr3_3_2 0 s3 x3_a2 0 -165906953046.27582
Gr4_3_2 0 s3 x4_a2 0 5642175297.224779
Gr5_3_2 0 s3 x5_a2 0 492987143.5507008
Gr6_3_2 0 s3 x6_a2 0 -9874339.18797898
Gd3_3 0 s3 p3 0 1.5878480614681668e-05
Fd3_3 0 s3 V3 0.0007939240307340835
Gr1_re_3_3 0 s3 x1_re_a3 0 84757276620.44801
Gr1_im_3_3 0 s3 x1_im_a3 0 -180626772938.8605
Gr2_3_3 0 s3 x2_a3 0 1443207751270.1272
Gr3_3_3 0 s3 x3_a3 0 -1293489755167.7905
Gr4_3_3 0 s3 x4_a3 0 -39748447563.12695
Gr5_3_3 0 s3 x5_a3 0 -490319476.9671721
Gr6_3_3 0 s3 x6_a3 0 2979867.6528994897
Gd3_4 0 s3 p4 0 -9.913571712245604e-06
Fd3_4 0 s3 V4 -0.0004956785856122803
Gr1_re_3_4 0 s3 x1_re_a4 0 54888517793.293045
Gr1_im_3_4 0 s3 x1_im_a4 0 344639638706.92914
Gr2_3_4 0 s3 x2_a4 0 -797324061223.9899
Gr3_3_4 0 s3 x3_a4 0 1006799969293.8801
Gr4_3_4 0 s3 x4_a4 0 21390653387.46095
Gr5_3_4 0 s3 x5_a4 0 -151886323.49340242
Gr6_3_4 0 s3 x6_a4 0 11502183.46398735
Gd3_5 0 s3 p5 0 -2.9060445322141477e-05
Fd3_5 0 s3 V5 -0.0014530222661070739
Gr1_re_3_5 0 s3 x1_re_a5 0 51167096780.71157
Gr1_im_3_5 0 s3 x1_im_a5 0 -26500784348.988445
Gr2_3_5 0 s3 x2_a5 0 875107371331.3154
Gr3_3_5 0 s3 x3_a5 0 -689670819600.9601
Gr4_3_5 0 s3 x4_a5 0 -7104466285.492143
Gr5_3_5 0 s3 x5_a5 0 -1423841425.124727
Gr6_3_5 0 s3 x6_a5 0 14125756.9702697
Gd3_6 0 s3 p6 0 -2.47446306950172e-06
Fd3_6 0 s3 V6 -0.000123723153475086
Gr1_re_3_6 0 s3 x1_re_a6 0 -174215333868.572
Gr1_im_3_6 0 s3 x1_im_a6 0 -99014009690.37866
Gr2_3_6 0 s3 x2_a6 0 14511644187.852535
Gr3_3_6 0 s3 x3_a6 0 170341394940.2395
Gr4_3_6 0 s3 x4_a6 0 20566356960.816998
Gr5_3_6 0 s3 x5_a6 0 943357312.3337144
Gr6_3_6 0 s3 x6_a6 0 -6075690.00147054
*
* State networks driven by port 3
Cx1_re_a3 x1_re_a3 0 1.0
Gx1_re_a3 0 x1_re_a3 p3 0 0.1414213562373095
Fx1_re_a3 0 x1_re_a3 V3 7.0710678118654755
Rp1_re_re_a3 0 x1_re_a3 6.142922187756332e-13
Gp1_re_im_a3 0 x1_re_a3 x1_im_a3 0 2394667911485.9653
Cx1_im_a3 x1_im_a3 0 1.0
Gp1_im_re_a3 0 x1_im_a3 x1_re_a3 0 -2394667911485.9653
Rp1_im_im_a3 0 x1_im_a3 6.142922187756332e-13
Cx2_a3 x2_a3 0 1.0
Gx2_a3 0 x2_a3 p3 0 0.07071067811865475
Fx2_a3 0 x2_a3 V3 3.5355339059327378
Rp2_a3 0 x2_a3 6.332657793113146e-13
Cx3_a3 x3_a3 0 1.0
Gx3_a3 0 x3_a3 p3 0 0.07071067811865475
Fx3_a3 0 x3_a3 V3 3.5355339059327378
Rp3_a3 0 x3_a3 8.173123325341146e-13
Cx4_a3 x4_a3 0 1.0
Gx4_a3 0 x4_a3 p3 0 0.07071067811865475
Fx4_a3 0 x4_a3 V3 3.5355339059327378
Rp4_a3 0 x4_a3 2.0209324389001855e-12
Cx5_a3 x5_a3 0 1.0
Gx5_a3 0 x5_a3 p3 0 0.07071067811865475
Fx5_a3 0 x5_a3 V3 3.5355339059327378
Rp5_a3 0 x5_a3 8.841371352254124e-12
Cx6_a3 x6_a3 0 1.0
Gx6_a3 0 x6_a3 p3 0 0.07071067811865475
Fx6_a3 0 x6_a3 V3 3.5355339059327378
Rp6_a3 0 x6_a3 2.4045900030032587e-10
*
* Port network for port 4
V4 p4 s4 0
R4 s4 0 50.0
Gd4_1 0 s4 p1 0 2.6255864922966174e-06
Fd4_1 0 s4 V1 0.00013127932461483088
Gr1_re_4_1 0 s4 x1_re_a1 0 -1448176339.3667185
Gr1_im_4_1 0 s4 x1_im_a1 0 -73206456718.85052
Gr2_4_1 0 s4 x2_a1 0 130026422664.44475
Gr3_4_1 0 s4 x3_a1 0 -167894287075.7417
Gr4_4_1 0 s4 x4_a1 0 5591409948.336096
Gr5_4_1 0 s4 x5_a1 0 420292416.57801914
Gr6_4_1 0 s4 x6_a1 0 -8578298.028972508
Gd4_2 0 s4 p2 0 1.0680920849434061e-05
Fd4_2 0 s4 V2 0.0005340460424717031
Gr1_re_4_2 0 s4 x1_re_a2 0 118231295771.63556
Gr1_im_4_2 0 s4 x1_im_a2 0 115437438324.112
Gr2_4_2 0 s4 x2_a2 0 -662825900522.5133
Gr3_4_2 0 s4 x3_a2 0 505069558153.3665
Gr4_4_2 0 s4 x4_a2 0 11449943108.787659
Gr5_4_2 0 s4 x5_a2 0 609619647.35719
Gr6_4_2 0 s4 x6_a2 0 -8759623.039931796
Gd4_3 0 s4 p3 0 -9.913571709341262e-06
Fd4_3 0 s4 V3 -0.0004956785854670631
Gr1_re_4_3 0 s4 x1_re_a3 0 54888517793.59702
Gr1_im_4_3 0 s4 x1_im_a3 0 344639638706.4353
Gr2_4_3 0 s4 x2_a3 0 -797324061227.0239
Gr3_4_3 0 s4 x3_a3 0 1006799969295.8811
Gr4_4_3 0 s4 x4_a3 0 21390653387.39829
Gr5_4_3 0 s4 x5_a3 0 -151886323.4904687
Gr6_4_3 0 s4 x6_a3 0 11502183.46382866
Gd4_4 0 s4 p4 0 1.4655609675212621e-05
Fd4_4 0 s4 V4 0.0007327804837606311
Gr1_re_4_4 0 s4 x1_re_a4 0 91460436475.7596
Gr1_im_4_4 0 s4 x1_im_a4 0 -189043045256.04684
Gr2_4_4 0 s4 x2_a4 0 1419606437802.745
Gr3_4_4 0 s4 x3_a4 0 -1288174824340.2778
Gr4_4_4 0 s4 x4_a4 0 -37762754019.835815
Gr5_4_4 0 s4 x5_a4 0 -593785496.0525447
Gr6_4_4 0 s4 x6_a4 0 3685321.2208167836
Gd4_5 0 s4 p5 0 -2.9999448138744208e-05
Fd4_5 0 s4 V5 -0.0014999724069372105
Gr1_re_4_5 0 s4 x1_re_a5 0 47889621020.68484
Gr1_im_4_5 0 s4 x1_im_a5 0 -265947677.99561906
Gr2_4_5 0 s4 x2_a5 0 899965644126.1013
Gr3_4_5 0 s4 x3_a5 0 -683075155807.6525
Gr4_4_5 0 s4 x4_a5 0 -9854026453.954819
Gr5_4_5 0 s4 x5_a5 0 -1345995689.4903624
Gr6_4_5 0 s4 x6_a5 0 13889310.953558717
Gd4_6 0 s4 p6 0 -2.012653819210009e-06
Fd4_6 0 s4 V6 -0.00010063269096050044
Gr1_re_4_6 0 s4 x1_re_a6 0 -189020288611.50876
Gr1_im_4_6 0 s4 x1_im_a6 0 -96033448652.84453
Gr2_4_6 0 s4 x2_a6 0 116884957953.29898
Gr3_4_6 0 s4 x3_a6 0 93035619610.93878
Gr4_4_6 0 s4 x4_a6 0 23954664834.909416
Gr5_4_6 0 s4 x5_a6 0 820761780.1115556
Gr6_4_6 0 s4 x6_a6 0 -5549437.2890942665
*
* State networks driven by port 4
Cx1_re_a4 x1_re_a4 0 1.0
Gx1_re_a4 0 x1_re_a4 p4 0 0.1414213562373095
Fx1_re_a4 0 x1_re_a4 V4 7.0710678118654755
Rp1_re_re_a4 0 x1_re_a4 6.142922187756332e-13
Gp1_re_im_a4 0 x1_re_a4 x1_im_a4 0 2394667911485.9653
Cx1_im_a4 x1_im_a4 0 1.0
Gp1_im_re_a4 0 x1_im_a4 x1_re_a4 0 -2394667911485.9653
Rp1_im_im_a4 0 x1_im_a4 6.142922187756332e-13
Cx2_a4 x2_a4 0 1.0
Gx2_a4 0 x2_a4 p4 0 0.07071067811865475
Fx2_a4 0 x2_a4 V4 3.5355339059327378
Rp2_a4 0 x2_a4 6.332657793113146e-13
Cx3_a4 x3_a4 0 1.0
Gx3_a4 0 x3_a4 p4 0 0.07071067811865475
Fx3_a4 0 x3_a4 V4 3.5355339059327378
Rp3_a4 0 x3_a4 8.173123325341146e-13
Cx4_a4 x4_a4 0 1.0
Gx4_a4 0 x4_a4 p4 0 0.07071067811865475
Fx4_a4 0 x4_a4 V4 3.5355339059327378
Rp4_a4 0 x4_a4 2.0209324389001855e-12
Cx5_a4 x5_a4 0 1.0
Gx5_a4 0 x5_a4 p4 0 0.07071067811865475
Fx5_a4 0 x5_a4 V4 3.5355339059327378
Rp5_a4 0 x5_a4 8.841371352254124e-12
Cx6_a4 x6_a4 0 1.0
Gx6_a4 0 x6_a4 p4 0 0.07071067811865475
Fx6_a4 0 x6_a4 V4 3.5355339059327378
Rp6_a4 0 x6_a4 2.4045900030032587e-10
*
* Port network for port 5
V5 p5 s5 0
R5 s5 0 50.0
Gd5_1 0 s5 p1 0 -1.2523134667210556e-05
Fd5_1 0 s5 V1 -0.0006261567333605278
Gr1_re_5_1 0 s5 x1_re_a1 0 -43930716668.48999
Gr1_im_5_1 0 s5 x1_im_a1 0 -158348406511.175
Gr2_5_1 0 s5 x2_a1 0 -420406476110.2823
Gr3_5_1 0 s5 x3_a1 0 404972112887.9426
Gr4_5_1 0 s5 x4_a1 0 16819369608.647545
Gr5_5_1 0 s5 x5_a1 0 1842428707.5772817
Gr6_5_1 0 s5 x6_a1 0 -11645080.296333693
Gd5_2 0 s5 p2 0 -9.110843830115734e-06
Fd5_2 0 s5 V2 -0.0004555421915057868
Gr1_re_5_2 0 s5 x1_re_a2 0 -39220711187.59445
Gr1_im_5_2 0 s5 x1_im_a2 0 -130821680350.26157
Gr2_5_2 0 s5 x2_a2 0 -536637248432.24005
Gr3_5_2 0 s5 x3_a2 0 504846292890.5409
Gr4_5_2 0 s5 x4_a2 0 19704650380.717083
Gr5_5_2 0 s5 x5_a2 0 1891928321.3725314
Gr6_5_2 0 s5 x6_a2 0 -13107711.280074563
Gd5_3 0 s5 p3 0 -2.9060445366615298e-05
Fd5_3 0 s5 V3 -0.001453022268330765
Gr1_re_5_3 0 s5 x1_re_a3 0 51167096781.60892
Gr1_im_5_3 0 s5 x1_im_a3 0 -26500784348.69984
Gr2_5_3 0 s5 x2_a3 0 875107371328.3798
Gr3_5_3 0 s5 x3_a3 0 -689670819598.8397
Gr4_5_3 0 s5 x4_a3 0 -7104466285.523144
Gr5_5_3 0 s5 x5_a3 0 -1423841425.1358018
Gr6_5_3 0 s5 x6_a3 0 14125756.972121999
Gd5_4 0 s5 p4 0 -2.999944821421848e-05
Fd5_4 0 s5 V4 -0.001499972410710924
Gr1_re_5_4 0 s5 x1_re_a4 0 47889621021.82818
Gr1_im_5_4 0 s5 x1_im_a4 0 -265947677.77670562
Gr2_5_4 0 s5 x2_a4 0 899965644121.5062
Gr3_5_4 0 s5 x3_a4 0 -683075155804.2714
Gr4_5_4 0 s5 x4_a4 0 -9854026454.046783
Gr5_5_4 0 s5 x5_a4 0 -1345995689.5011256
Gr6_5_4 0 s5 x6_a4 0 13889310.957413195
Gd5_5 0 s5 p5 0 2.5580575703912923e-05
Fd5_5 0 s5 V5 0.0012790287851956461
Gr1_re_5_5 0 s5 x1_re_a5 0 118559092386.79866
Gr1_im_5_5 0 s5 x1_im_a5 0 261243682515.2273
Gr2_5_5 0 s5 x2_a5 0 1013740656979.5039
Gr3_5_5 0 s5 x3_a5 0 -511601630824.988
Gr4_5_5 0 s5 x4_a5 0 -100616909814.47137
Gr5_5_5 0 s5 x5_a5 0 -1142301298.3947055
Gr6_5_5 0 s5 x6_a5 0 9204953.462861499
Gd5_6 0 s5 p6 0 3.4824081193048464e-05
Fd5_6 0 s5 V6 0.0017412040596524235
Gr1_re_5_6 0 s5 x1_re_a6 0 250573955009.0721
Gr1_im_5_6 0 s5 x1_im_a6 0 98860980135.67448
Gr2_5_6 0 s5 x2_a6 0 -908903495992.5155
Gr3_5_6 0 s5 x3_a6 0 405759654956.49243
Gr4_5_6 0 s5 x4_a6 0 97790538750.38025
Gr5_5_6 0 s5 x5_a6 0 450870642.52489614
Gr6_5_6 0 s5 x6_a6 0 -5106240.965225809
*
* State networks driven by port 5
Cx1_re_a5 x1_re_a5 0 1.0
Gx1_re_a5 0 x1_re_a5 p5 0 0.1414213562373095
Fx1_re_a5 0 x1_re_a5 V5 7.0710678118654755
Rp1_re_re_a5 0 x1_re_a5 6.142922187756332e-13
Gp1_re_im_a5 0 x1_re_a5 x1_im_a5 0 2394667911485.9653
Cx1_im_a5 x1_im_a5 0 1.0
Gp1_im_re_a5 0 x1_im_a5 x1_re_a5 0 -2394667911485.9653
Rp1_im_im_a5 0 x1_im_a5 6.142922187756332e-13
Cx2_a5 x2_a5 0 1.0
Gx2_a5 0 x2_a5 p5 0 0.07071067811865475
Fx2_a5 0 x2_a5 V5 3.5355339059327378
Rp2_a5 0 x2_a5 6.332657793113146e-13
Cx3_a5 x3_a5 0 1.0
Gx3_a5 0 x3_a5 p5 0 0.07071067811865475
Fx3_a5 0 x3_a5 V5 3.5355339059327378
Rp3_a5 0 x3_a5 8.173123325341146e-13
Cx4_a5 x4_a5 0 1.0
Gx4_a5 0 x4_a5 p5 0 0.07071067811865475
Fx4_a5 0 x4_a5 V5 3.5355339059327378
Rp4_a5 0 x4_a5 2.0209324389001855e-12
Cx5_a5 x5_a5 0 1.0
Gx5_a5 0 x5_a5 p5 0 0.07071067811865475
Fx5_a5 0 x5_a5 V5 3.5355339059327378
Rp5_a5 0 x5_a5 8.841371352254124e-12
Cx6_a5 x6_a5 0 1.0
Gx6_a5 0 x6_a5 p5 0 0.07071067811865475
Fx6_a5 0 x6_a5 V5 3.5355339059327378
Rp6_a5 0 x6_a5 2.4045900030032587e-10
*
* Port network for port 6
V6 p6 s6 0
R6 s6 0 50.0
Gd6_1 0 s6 p1 0 -2.483084370092084e-05
Fd6_1 0 s6 V1 -0.0012415421850460419
Gr1_re_6_1 0 s6 x1_re_a1 0 79979986175.86258
Gr1_im_6_1 0 s6 x1_im_a1 0 172300428122.31177
Gr2_6_1 0 s6 x2_a1 0 1152933387749.7715
Gr3_6_1 0 s6 x3_a1 0 -774693588231.4508
Gr4_6_1 0 s6 x4_a1 0 -8385830426.243623
Gr5_6_1 0 s6 x5_a1 0 -1499436499.7341897
Gr6_6_1 0 s6 x6_a1 0 11360542.594826441
Gd6_2 0 s6 p2 0 -3.07363722288654e-05
Fd6_2 0 s6 V2 -0.0015368186114432698
Gr1_re_6_2 0 s6 x1_re_a2 0 48571149048.651436
Gr1_im_6_2 0 s6 x1_im_a2 0 133185214663.57655
Gr2_6_2 0 s6 x2_a2 0 1027797366735.4592
Gr3_6_2 0 s6 x3_a2 0 -669704761832.5867
Gr4_6_2 0 s6 x4_a2 0 -17256844762.641468
Gr5_6_2 0 s6 x5_a2 0 -1353198330.9831972
Gr6_6_2 0 s6 x6_a2 0 10907150.495830119
Gd6_3 0 s6 p3 0 -2.4744630698680935e-06
Fd6_3 0 s6 V3 -0.00012372315349340468
Gr1_re_6_3 0 s6 x1_re_a3 0 -174215333869.5358
Gr1_im_6_3 0 s6 x1_im_a3 0 -99014009689.84227
Gr2_6_3 0 s6 x2_a3 0 14511644195.421556
Gr3_6_3 0 s6 x3_a3 0 170341394934.5902
Gr4_6_3 0 s6 x4_a3 0 20566356961.092857
Gr5_6_3 0 s6 x5_a3 0 943357312.3217397
Gr6_6_3 0 s6 x6_a3 0 -6075690.001307438
Gd6_4 0 s6 p4 0 -2.012653822960342e-06
Fd6_4 0 s6 V4 -0.00010063269114801711
Gr1_re_6_4 0 s6 x1_re_a4 0 -189020288612.91702
Gr1_im_6_4 0 s6 x1_im_a4 0 -96033448651.71045
Gr2_6_4 0 s6 x2_a4 0 116884957964.37346
Gr3_6_4 0 s6 x3_a4 0 93035619603.13629
Gr4_6_4 0 s6 x4_a4 0 23954664835.19985
Gr5_6_4 0 s6 x5_a4 0 820761780.1015825
Gr6_6_4 0 s6 x6_a4 0 -5549437.288790494
Gd6_5 0 s6 p5 0 3.482408119324927e-05
Fd6_5 0 s6 V5 0.0017412040596624639
Gr1_re_6_5 0 s6 x1_re_a5 0 250573955007.7077
Gr1_im_6_5 0 s6 x1_im_a5 0 98860980135.86172
Gr2_6_5 0 s6 x2_a5 0 -908903495986.9563
Gr3_6_5 0 s6 x3_a5 0 405759654952.9264
Gr4_6_5 0 s6 x4_a5 0 97790538750.37184
Gr5_6_5 0 s6 x5_a5 0 450870642.54575366
Gr6_6_5 0 s6 x6_a5 0 -5106240.966832893
Gd6_6 0 s6 p6 0 8.754040689490373e-06
Fd6_6 0 s6 V6 0.00043770203447451866
Gr1_re_6_6 0 s6 x1_re_a6 0 -50875900554.42247
Gr1_im_6_6 0 s6 x1_im_a6 0 -371989442976.45605
Gr2_6_6 0 s6 x2_a6 0 -556081411255.3523
Gr3_6_6 0 s6 x3_a6 0 359519988729.91064
Gr4_6_6 0 s6 x4_a6 0 -111478144723.31595
Gr5_6_6 0 s6 x5_a6 0 94734269.69421414
Gr6_6_6 0 s6 x6_a6 0 -555302.692397907
*
* State networks driven by port 6
Cx1_re_a6 x1_re_a6 0 1.0
Gx1_re_a6 0 x1_re_a6 p6 0 0.1414213562373095
Fx1_re_a6 0 x1_re_a6 V6 7.0710678118654755
Rp1_re_re_a6 0 x1_re_a6 6.142922187756332e-13
Gp1_re_im_a6 0 x1_re_a6 x1_im_a6 0 2394667911485.9653
Cx1_im_a6 x1_im_a6 0 1.0
Gp1_im_re_a6 0 x1_im_a6 x1_re_a6 0 -2394667911485.9653
Rp1_im_im_a6 0 x1_im_a6 6.142922187756332e-13
Cx2_a6 x2_a6 0 1.0
Gx2_a6 0 x2_a6 p6 0 0.07071067811865475
Fx2_a6 0 x2_a6 V6 3.5355339059327378
Rp2_a6 0 x2_a6 6.332657793113146e-13
Cx3_a6 x3_a6 0 1.0
Gx3_a6 0 x3_a6 p6 0 0.07071067811865475
Fx3_a6 0 x3_a6 V6 3.5355339059327378
Rp3_a6 0 x3_a6 8.173123325341146e-13
Cx4_a6 x4_a6 0 1.0
Gx4_a6 0 x4_a6 p6 0 0.07071067811865475
Fx4_a6 0 x4_a6 V6 3.5355339059327378
Rp4_a6 0 x4_a6 2.0209324389001855e-12
Cx5_a6 x5_a6 0 1.0
Gx5_a6 0 x5_a6 p6 0 0.07071067811865475
Fx5_a6 0 x5_a6 V6 3.5355339059327378
Rp5_a6 0 x5_a6 8.841371352254124e-12
Cx6_a6 x6_a6 0 1.0
Gx6_a6 0 x6_a6 p6 0 0.07071067811865475
Fx6_a6 0 x6_a6 V6 3.5355339059327378
Rp6_a6 0 x6_a6 2.4045900030032587e-10
.ENDS s_equivalent

.PARAM Cout = 44f
V1 Vdd 0 DC 2.5
L1 _net0 _net1  100P
C1 0 on  {COUT}
L2 _net2 _net1  40.000P
Xnpn13G1 0 _net0 _net0 0 sub IHP_PDK_nonlinear_components_npn13G2 Nx=1
R1 _net3 Vdd  3K tc1=0.0 tc2=0.0
R2 0 _net3  13K tc1=0.0 tc2=0.0
R3 _net0 Vdd  2.5K tc1=0.0 tc2=0.0
C2 0 _net0  200F
C3 0 _net2  38F
C4 _net4 _net2  300F
C5 0 _net3  72F
Xnpn13G2 0 _net5 _net1 0 sub IHP_PDK_nonlinear_components_npn13G2 Nx=8
Xnpn13G3 0 ip _net3 _net5 sub IHP_PDK_nonlinear_components_npn13G2 Nx=8
Xptap1 0 sub 0 IHP_PDK_basic_components_ptap1 w=0.78U l=0.78U
XSUB1 Out Vdd on op 0 ideal_balun
C6 0 op  {COUT}
X2 ip Vdd op on _net8 _net9 s_equivalent

P1 _net4 0 port=1  z0=50  AC 0.063245553  SIN 0 0.063245553 130G
VOut Out _net10 DC 0
R4 0 _net10  100 tc1=0.0 tc2=0.0
P2 _net10 0 port=2  z0=100  AC 0.89442719  SIN 0 0.89442719 0G
.tran 1.50075e-13 3e-10 0 1.50075e-13
.PRINT  tran format=raw file=spice4qucs.tran.plot I(VOut) v(Out) v(Vdd) v(ip) v(on) v(op) v(sub)
.END
