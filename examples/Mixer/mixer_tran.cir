* Qucs 26.1.0  /home/users/simone/Hiwi/MixerExample/Example_schematic_Mixer_COBRA_xyce.sch
.INCLUDE "/usr/local/share/qucs-s/spicelibrary/xfmr.cir"
.LIB "/home/users/simone/IHP-Open-PDK/ihp-sg13g2/libs.tech/xyce/models/cornerHBT.lib" hbt_typ
.LIB "/home/users/simone/IHP-Open-PDK/ihp-sg13g2/libs.tech/xyce/models/resistors_mod.lib" hbt_typ

.SUBCKT IHP_PDK_nonlinear_components_npn13G2  gnd c b e bn Nx=1
X1 c b e bn npn13G2 Nx={Nx}
.ENDS

.SUBCKT ideal_balun _net1 _net4 _net3 _net0 _net2
X_Tr1_W1 _net1 _net2 _net4 _net3  XFMR RATIO=0.5
X_Tr1_W2 _net1 _net2 _net0 _net4  XFMR RATIO=0.5
.ENDS

* EQUIVALENT CIRCUIT FOR VECTOR FITTED S-MATRIX
* Created using scikit-rf vectorFitting.py
*
.SUBCKT s_equivalent90 p1 p2 p3 p4 p5 p6 p7 p8
*
* Port network for port 1
V1 p1 s1 0
R1 s1 0 50.0
Gd1_1 0 s1 p1 0 8.428318761410924e-07
Fd1_1 0 s1 V1 4.214159380705462e-05
Gr1_1_1 0 s1 x1_a1 0 -6030869356075.574
Gr2_re_1_1 0 s1 x2_re_a1 0 77310761435.40947
Gr2_im_1_1 0 s1 x2_im_a1 0 149889091661.76154
Gr3_re_1_1 0 s1 x3_re_a1 0 -20995110841.979115
Gr3_im_1_1 0 s1 x3_im_a1 0 -55090156792.62132
Gr4_re_1_1 0 s1 x4_re_a1 0 -394476523091.41907
Gr4_im_1_1 0 s1 x4_im_a1 0 -2636383484.246597
Gr5_re_1_1 0 s1 x5_re_a1 0 1745518343964.4646
Gr5_im_1_1 0 s1 x5_im_a1 0 2321473917467.933
Gr6_re_1_1 0 s1 x6_re_a1 0 -25710418661.843857
Gr6_im_1_1 0 s1 x6_im_a1 0 -8118347257.592198
Gr7_re_1_1 0 s1 x7_re_a1 0 -154900264.28485155
Gr7_im_1_1 0 s1 x7_im_a1 0 -78844542.70643806
Gr8_1_1 0 s1 x8_a1 0 1706214789841.626
Gr9_re_1_1 0 s1 x9_re_a1 0 -407661435249.04095
Gr9_im_1_1 0 s1 x9_im_a1 0 358115278829.3884
Gr10_1_1 0 s1 x10_a1 0 1664321280165.1428
Gr11_1_1 0 s1 x11_a1 0 -725942372315.8378
Gr12_1_1 0 s1 x12_a1 0 179149229972.67014
Gr13_re_1_1 0 s1 x13_re_a1 0 -3028029779.0027957
Gr13_im_1_1 0 s1 x13_im_a1 0 -940099344.4618295
Gr14_1_1 0 s1 x14_a1 0 -14761653775.334194
Gr15_1_1 0 s1 x15_a1 0 924062715.9785578
Gr16_re_1_1 0 s1 x16_re_a1 0 -4432280.854010841
Gr16_im_1_1 0 s1 x16_im_a1 0 42602451.09472978
Gd1_2 0 s1 p2 0 3.5294146189190906e-07
Fd1_2 0 s1 V2 1.7647073094595456e-05
Gr1_1_2 0 s1 x1_a2 0 -1154884288886.685
Gr2_re_1_2 0 s1 x2_re_a2 0 -181800030582.04172
Gr2_im_1_2 0 s1 x2_im_a2 0 -175133520566.18912
Gr3_re_1_2 0 s1 x3_re_a2 0 -35198650960.5811
Gr3_im_1_2 0 s1 x3_im_a2 0 -19842952016.695812
Gr4_re_1_2 0 s1 x4_re_a2 0 -57235767324.70588
Gr4_im_1_2 0 s1 x4_im_a2 0 408164148169.1935
Gr5_re_1_2 0 s1 x5_re_a2 0 2528731510834.0825
Gr5_im_1_2 0 s1 x5_im_a2 0 -684997480055.4578
Gr6_re_1_2 0 s1 x6_re_a2 0 -20862855445.614
Gr6_im_1_2 0 s1 x6_im_a2 0 17447475053.336475
Gr7_re_1_2 0 s1 x7_re_a2 0 -215597294.9331966
Gr7_im_1_2 0 s1 x7_im_a2 0 43740363.41418074
Gr8_1_2 0 s1 x8_a2 0 -24983864422799.75
Gr9_re_1_2 0 s1 x9_re_a2 0 -119199542927.72668
Gr9_im_1_2 0 s1 x9_im_a2 0 1073074539913.3646
Gr10_1_2 0 s1 x10_a2 0 24027061368984.426
Gr11_1_2 0 s1 x11_a2 0 -2824279611686.9946
Gr12_1_2 0 s1 x12_a2 0 575062049399.9355
Gr13_re_1_2 0 s1 x13_re_a2 0 -8602593150.560497
Gr13_im_1_2 0 s1 x13_im_a2 0 -3151399447.4089875
Gr14_1_2 0 s1 x14_a2 0 -46038051459.327545
Gr15_1_2 0 s1 x15_a2 0 3414384881.4464273
Gr16_re_1_2 0 s1 x16_re_a2 0 -55624453.60300027
Gr16_im_1_2 0 s1 x16_im_a2 0 -32237356.08090817
Gd1_3 0 s1 p3 0 5.627358263815552e-07
Fd1_3 0 s1 V3 2.813679131907776e-05
Gr1_1_3 0 s1 x1_a3 0 560462634403.157
Gr2_re_1_3 0 s1 x2_re_a3 0 13174439905.738962
Gr2_im_1_3 0 s1 x2_im_a3 0 -62726887733.59448
Gr3_re_1_3 0 s1 x3_re_a3 0 -16609700104.731602
Gr3_im_1_3 0 s1 x3_im_a3 0 -12351821516.139114
Gr4_re_1_3 0 s1 x4_re_a3 0 -141848921494.89926
Gr4_im_1_3 0 s1 x4_im_a3 0 5419877440.856715
Gr5_re_1_3 0 s1 x5_re_a3 0 -152697757960.04282
Gr5_im_1_3 0 s1 x5_im_a3 0 470803571021.22595
Gr6_re_1_3 0 s1 x6_re_a3 0 -27250499349.776142
Gr6_im_1_3 0 s1 x6_im_a3 0 -1932243595.3617954
Gr7_re_1_3 0 s1 x7_re_a3 0 -23290332.14303757
Gr7_im_1_3 0 s1 x7_im_a3 0 -22074805.79587575
Gr8_1_3 0 s1 x8_a3 0 2067414031864.281
Gr9_re_1_3 0 s1 x9_re_a3 0 -94577617325.51099
Gr9_im_1_3 0 s1 x9_im_a3 0 -82115092801.69711
Gr10_1_3 0 s1 x10_a3 0 -1284756416023.2954
Gr11_1_3 0 s1 x11_a3 0 36437661963.261116
Gr12_1_3 0 s1 x12_a3 0 2220896781.6365805
Gr13_re_1_3 0 s1 x13_re_a3 0 -183848247.80369434
Gr13_im_1_3 0 s1 x13_im_a3 0 49903700.50621117
Gr14_1_3 0 s1 x14_a3 0 203603342.9893421
Gr15_1_3 0 s1 x15_a3 0 -185221656.3425089
Gr16_re_1_3 0 s1 x16_re_a3 0 14611079.010457994
Gr16_im_1_3 0 s1 x16_im_a3 0 70270585.96132483
Gd1_4 0 s1 p4 0 6.019373819710071e-07
Fd1_4 0 s1 V4 3.0096869098550357e-05
Gr1_1_4 0 s1 x1_a4 0 587799469145.9215
Gr2_re_1_4 0 s1 x2_re_a4 0 13632522711.082876
Gr2_im_1_4 0 s1 x2_im_a4 0 -61278073816.44072
Gr3_re_1_4 0 s1 x3_re_a4 0 -16777692479.055649
Gr3_im_1_4 0 s1 x3_im_a4 0 -12087866544.222267
Gr4_re_1_4 0 s1 x4_re_a4 0 -139035322998.218
Gr4_im_1_4 0 s1 x4_im_a4 0 5198815105.419409
Gr5_re_1_4 0 s1 x5_re_a4 0 -154022627279.9865
Gr5_im_1_4 0 s1 x5_im_a4 0 448919343249.1656
Gr6_re_1_4 0 s1 x6_re_a4 0 -27217974078.26218
Gr6_im_1_4 0 s1 x6_im_a4 0 -1909942550.2427633
Gr7_re_1_4 0 s1 x7_re_a4 0 -20897748.342619836
Gr7_im_1_4 0 s1 x7_im_a4 0 -21209347.33286455
Gr8_1_4 0 s1 x8_a4 0 1973847061267.604
Gr9_re_1_4 0 s1 x9_re_a4 0 -92403405686.81052
Gr9_im_1_4 0 s1 x9_im_a4 0 -80238603816.78992
Gr10_1_4 0 s1 x10_a4 0 -1219668940919.5554
Gr11_1_4 0 s1 x11_a4 0 32671277528.059395
Gr12_1_4 0 s1 x12_a4 0 2815533760.3662486
Gr13_re_1_4 0 s1 x13_re_a4 0 -190163736.04992506
Gr13_im_1_4 0 s1 x13_im_a4 0 43687940.217825025
Gr14_1_4 0 s1 x14_a4 0 143072676.11805895
Gr15_1_4 0 s1 x15_a4 0 -177472516.65460557
Gr16_re_1_4 0 s1 x16_re_a4 0 14247165.316247815
Gr16_im_1_4 0 s1 x16_im_a4 0 69106486.06316507
Gd1_5 0 s1 p5 0 5.496084387630189e-07
Fd1_5 0 s1 V5 2.7480421938150947e-05
Gr1_1_5 0 s1 x1_a5 0 746688892638.1573
Gr2_re_1_5 0 s1 x2_re_a5 0 50568991911.27384
Gr2_im_1_5 0 s1 x2_im_a5 0 126140575658.27365
Gr3_re_1_5 0 s1 x3_re_a5 0 12429148417.387766
Gr3_im_1_5 0 s1 x3_im_a5 0 25114293148.020756
Gr4_re_1_5 0 s1 x4_re_a5 0 165647262505.4652
Gr4_im_1_5 0 s1 x4_im_a5 0 -191522605476.70404
Gr5_re_1_5 0 s1 x5_re_a5 0 -645535358679.1371
Gr5_im_1_5 0 s1 x5_im_a5 0 -300771511664.7921
Gr6_re_1_5 0 s1 x6_re_a5 0 -14295398994.082832
Gr6_im_1_5 0 s1 x6_im_a5 0 1938110150.4016175
Gr7_re_1_5 0 s1 x7_re_a5 0 99089607.11968642
Gr7_im_1_5 0 s1 x7_im_a5 0 5781692.4479054725
Gr8_1_5 0 s1 x8_a5 0 5976213804512.602
Gr9_re_1_5 0 s1 x9_re_a5 0 157960598580.77646
Gr9_im_1_5 0 s1 x9_im_a5 0 -233049428589.82706
Gr10_1_5 0 s1 x10_a5 0 -6454064587892.067
Gr11_1_5 0 s1 x11_a5 0 881858931573.627
Gr12_1_5 0 s1 x12_a5 0 -180791916140.27853
Gr13_re_1_5 0 s1 x13_re_a5 0 2710969129.041201
Gr13_im_1_5 0 s1 x13_im_a5 0 791896742.8593222
Gr14_1_5 0 s1 x14_a5 0 13694879356.7993
Gr15_1_5 0 s1 x15_a5 0 -1000053044.3267783
Gr16_re_1_5 0 s1 x16_re_a5 0 17815835.46200547
Gr16_im_1_5 0 s1 x16_im_a5 0 21124646.907779403
Gd1_6 0 s1 p6 0 -1.2786549450754734e-07
Fd1_6 0 s1 V6 -6.393274725377367e-06
Gr1_1_6 0 s1 x1_a6 0 5190937068185.853
Gr2_re_1_6 0 s1 x2_re_a6 0 -31312704614.411236
Gr2_im_1_6 0 s1 x2_im_a6 0 -109934129367.83134
Gr3_re_1_6 0 s1 x3_re_a6 0 -817556724.9667463
Gr3_im_1_6 0 s1 x3_im_a6 0 53980350413.2597
Gr4_re_1_6 0 s1 x4_re_a6 0 484307312551.1075
Gr4_im_1_6 0 s1 x4_im_a6 0 158604618420.7691
Gr5_re_1_6 0 s1 x5_re_a6 0 -368939676666.9987
Gr5_im_1_6 0 s1 x5_im_a6 0 -3475120851326.72
Gr6_re_1_6 0 s1 x6_re_a6 0 -11780232838.65831
Gr6_im_1_6 0 s1 x6_im_a6 0 -3747398633.939096
Gr7_re_1_6 0 s1 x7_re_a6 0 53738059.343336836
Gr7_im_1_6 0 s1 x7_im_a6 0 125617495.404635
Gr8_1_6 0 s1 x8_a6 0 -19977955204910.812
Gr9_re_1_6 0 s1 x9_re_a6 0 471887319016.4982
Gr9_im_1_6 0 s1 x9_im_a6 0 412139136851.4887
Gr10_1_6 0 s1 x10_a6 0 14873557306966.82
Gr11_1_6 0 s1 x11_a6 0 -1053333548181.3762
Gr12_1_6 0 s1 x12_a6 0 179614521526.2717
Gr13_re_1_6 0 s1 x13_re_a6 0 -2182622677.0209336
Gr13_im_1_6 0 s1 x13_im_a6 0 -1324928787.5530877
Gr14_1_6 0 s1 x14_a6 0 -15559581735.70716
Gr15_1_6 0 s1 x15_a6 0 1633137883.7383704
Gr16_re_1_6 0 s1 x16_re_a6 0 -57938594.83113858
Gr16_im_1_6 0 s1 x16_im_a6 0 -167178955.68523845
Gd1_7 0 s1 p7 0 1.4477851229795573e-07
Fd1_7 0 s1 V7 7.2389256148977865e-06
Gr1_1_7 0 s1 x1_a7 0 1055417969466.0333
Gr2_re_1_7 0 s1 x2_re_a7 0 -15001525807.937325
Gr2_im_1_7 0 s1 x2_im_a7 0 -66565052256.85899
Gr3_re_1_7 0 s1 x3_re_a7 0 -811256102.696845
Gr3_im_1_7 0 s1 x3_im_a7 0 4707479282.089559
Gr4_re_1_7 0 s1 x4_re_a7 0 81892780535.18694
Gr4_im_1_7 0 s1 x4_im_a7 0 111341539574.83081
Gr5_re_1_7 0 s1 x5_re_a7 0 162409345241.12122
Gr5_im_1_7 0 s1 x5_im_a7 0 -832157925793.0145
Gr6_re_1_7 0 s1 x6_re_a7 0 -24227811377.83279
Gr6_im_1_7 0 s1 x6_im_a7 0 -5322056756.755579
Gr7_re_1_7 0 s1 x7_re_a7 0 -29100599.32007332
Gr7_im_1_7 0 s1 x7_im_a7 0 24921513.698402733
Gr8_1_7 0 s1 x8_a7 0 -6912158605522.742
Gr9_re_1_7 0 s1 x9_re_a7 0 79365832645.79655
Gr9_im_1_7 0 s1 x9_im_a7 0 309657896416.23914
Gr10_1_7 0 s1 x10_a7 0 5931558444004.817
Gr11_1_7 0 s1 x11_a7 0 -574338415942.4857
Gr12_1_7 0 s1 x12_a7 0 104618471380.82376
Gr13_re_1_7 0 s1 x13_re_a7 0 -1395260072.253712
Gr13_im_1_7 0 s1 x13_im_a7 0 -377047485.4965306
Gr14_1_7 0 s1 x14_a7 0 -7405937654.735379
Gr15_1_7 0 s1 x15_a7 0 585302098.0747406
Gr16_re_1_7 0 s1 x16_re_a7 0 -11295611.617605738
Gr16_im_1_7 0 s1 x16_im_a7 0 -27134338.980091304
Gd1_8 0 s1 p8 0 1.9573748108809434e-07
Fd1_8 0 s1 V8 9.786874054404718e-06
Gr1_1_8 0 s1 x1_a8 0 1030763145289.5645
Gr2_re_1_8 0 s1 x2_re_a8 0 -17586277244.738106
Gr2_im_1_8 0 s1 x2_im_a8 0 -67174960992.07035
Gr3_re_1_8 0 s1 x3_re_a8 0 -1020303549.4484009
Gr3_im_1_8 0 s1 x3_im_a8 0 4667248786.767194
Gr4_re_1_8 0 s1 x4_re_a8 0 81535946747.05568
Gr4_im_1_8 0 s1 x4_im_a8 0 113645527618.72766
Gr5_re_1_8 0 s1 x5_re_a8 0 170693636283.36435
Gr5_im_1_8 0 s1 x5_im_a8 0 -820466038626.2219
Gr6_re_1_8 0 s1 x6_re_a8 0 -24242913392.757614
Gr6_im_1_8 0 s1 x6_im_a8 0 -5315782502.693696
Gr7_re_1_8 0 s1 x7_re_a8 0 -27621705.76042137
Gr7_im_1_8 0 s1 x7_im_a8 0 25458913.942970965
Gr8_1_8 0 s1 x8_a8 0 -6897787891408.426
Gr9_re_1_8 0 s1 x9_re_a8 0 78035269859.626
Gr9_im_1_8 0 s1 x9_im_a8 0 310438486775.96136
Gr10_1_8 0 s1 x10_a8 0 5932744601301.577
Gr11_1_8 0 s1 x11_a8 0 -576977114199.755
Gr12_1_8 0 s1 x12_a8 0 105345282703.377
Gr13_re_1_8 0 s1 x13_re_a8 0 -1407841183.5282788
Gr13_im_1_8 0 s1 x13_im_a8 0 -383293746.5220338
Gr14_1_8 0 s1 x14_a8 0 -7476685610.385121
Gr15_1_8 0 s1 x15_a8 0 591024720.0630132
Gr16_re_1_8 0 s1 x16_re_a8 0 -11379700.949519947
Gr16_im_1_8 0 s1 x16_im_a8 0 -27265287.06202429
*
* State networks driven by port 1
Cx1_a1 x1_a1 0 1.0
Gx1_a1 0 x1_a1 p1 0 0.07071067811865475
Fx1_a1 0 x1_a1 V1 3.5355339059327378
Rp1_a1 0 x1_a1 1.2667707539388034e-13
Cx2_re_a1 x2_re_a1 0 1.0
Gx2_re_a1 0 x2_re_a1 p1 0 0.1414213562373095
Fx2_re_a1 0 x2_re_a1 V1 7.0710678118654755
Rp2_re_re_a1 0 x2_re_a1 9.289804648696368e-13
Gp2_re_im_a1 0 x2_re_a1 x2_im_a1 0 3958398257259.3657
Cx2_im_a1 x2_im_a1 0 1.0
Gp2_im_re_a1 0 x2_im_a1 x2_re_a1 0 -3958398257259.3657
Rp2_im_im_a1 0 x2_im_a1 9.289804648696368e-13
Cx3_re_a1 x3_re_a1 0 1.0
Gx3_re_a1 0 x3_re_a1 p1 0 0.1414213562373095
Fx3_re_a1 0 x3_re_a1 V1 7.0710678118654755
Rp3_re_re_a1 0 x3_re_a1 1.8873881915204676e-12
Gp3_re_im_a1 0 x3_re_a1 x3_im_a1 0 3441166588437.5947
Cx3_im_a1 x3_im_a1 0 1.0
Gp3_im_re_a1 0 x3_im_a1 x3_re_a1 0 -3441166588437.5947
Rp3_im_im_a1 0 x3_im_a1 1.8873881915204676e-12
Cx4_re_a1 x4_re_a1 0 1.0
Gx4_re_a1 0 x4_re_a1 p1 0 0.1414213562373095
Fx4_re_a1 0 x4_re_a1 V1 7.0710678118654755
Rp4_re_re_a1 0 x4_re_a1 9.922592044099783e-13
Gp4_re_im_a1 0 x4_re_a1 x4_im_a1 0 3220889250610.056
Cx4_im_a1 x4_im_a1 0 1.0
Gp4_im_re_a1 0 x4_im_a1 x4_re_a1 0 -3220889250610.056
Rp4_im_im_a1 0 x4_im_a1 9.922592044099783e-13
Cx5_re_a1 x5_re_a1 0 1.0
Gx5_re_a1 0 x5_re_a1 p1 0 0.1414213562373095
Fx5_re_a1 0 x5_re_a1 V1 7.0710678118654755
Rp5_re_re_a1 0 x5_re_a1 4.2837375484112484e-13
Gp5_re_im_a1 0 x5_re_a1 x5_im_a1 0 2073506969966.306
Cx5_im_a1 x5_im_a1 0 1.0
Gp5_im_re_a1 0 x5_im_a1 x5_re_a1 0 -2073506969966.306
Rp5_im_im_a1 0 x5_im_a1 4.2837375484112484e-13
Cx6_re_a1 x6_re_a1 0 1.0
Gx6_re_a1 0 x6_re_a1 p1 0 0.1414213562373095
Fx6_re_a1 0 x6_re_a1 V1 7.0710678118654755
Rp6_re_re_a1 0 x6_re_a1 2.8457065637511862e-12
Gp6_re_im_a1 0 x6_re_a1 x6_im_a1 0 2302996887167.347
Cx6_im_a1 x6_im_a1 0 1.0
Gp6_im_re_a1 0 x6_im_a1 x6_re_a1 0 -2302996887167.347
Rp6_im_im_a1 0 x6_im_a1 2.8457065637511862e-12
Cx7_re_a1 x7_re_a1 0 1.0
Gx7_re_a1 0 x7_re_a1 p1 0 0.1414213562373095
Fx7_re_a1 0 x7_re_a1 V1 7.0710678118654755
Rp7_re_re_a1 0 x7_re_a1 1.764884203986438e-11
Gp7_re_im_a1 0 x7_re_a1 x7_im_a1 0 1893361683671.1223
Cx7_im_a1 x7_im_a1 0 1.0
Gp7_im_re_a1 0 x7_im_a1 x7_re_a1 0 -1893361683671.1223
Rp7_im_im_a1 0 x7_im_a1 1.764884203986438e-11
Cx8_a1 x8_a1 0 1.0
Gx8_a1 0 x8_a1 p1 0 0.07071067811865475
Fx8_a1 0 x8_a1 V1 3.5355339059327378
Rp8_a1 0 x8_a1 7.134017483278191e-13
Cx9_re_a1 x9_re_a1 0 1.0
Gx9_re_a1 0 x9_re_a1 p1 0 0.1414213562373095
Fx9_re_a1 0 x9_re_a1 V1 7.0710678118654755
Rp9_re_re_a1 0 x9_re_a1 1.1810108382102504e-12
Gp9_re_im_a1 0 x9_re_a1 x9_im_a1 0 667262162732.5848
Cx9_im_a1 x9_im_a1 0 1.0
Gp9_im_re_a1 0 x9_im_a1 x9_re_a1 0 -667262162732.5848
Rp9_im_im_a1 0 x9_im_a1 1.1810108382102504e-12
Cx10_a1 x10_a1 0 1.0
Gx10_a1 0 x10_a1 p1 0 0.07071067811865475
Fx10_a1 0 x10_a1 V1 3.5355339059327378
Rp10_a1 0 x10_a1 9.059895014373575e-13
Cx11_a1 x11_a1 0 1.0
Gx11_a1 0 x11_a1 p1 0 0.07071067811865475
Fx11_a1 0 x11_a1 V1 3.5355339059327378
Rp11_a1 0 x11_a1 1.7461165062812219e-12
Cx12_a1 x12_a1 0 1.0
Gx12_a1 0 x12_a1 p1 0 0.07071067811865475
Fx12_a1 0 x12_a1 V1 3.5355339059327378
Rp12_a1 0 x12_a1 2.9716792303835088e-12
Cx13_re_a1 x13_re_a1 0 1.0
Gx13_re_a1 0 x13_re_a1 p1 0 0.1414213562373095
Fx13_re_a1 0 x13_re_a1 V1 7.0710678118654755
Rp13_re_re_a1 0 x13_re_a1 8.809235095423119e-12
Gp13_re_im_a1 0 x13_re_a1 x13_im_a1 0 123160380596.87326
Cx13_im_a1 x13_im_a1 0 1.0
Gp13_im_re_a1 0 x13_im_a1 x13_re_a1 0 -123160380596.87326
Rp13_im_im_a1 0 x13_im_a1 8.809235095423119e-12
Cx14_a1 x14_a1 0 1.0
Gx14_a1 0 x14_a1 p1 0 0.07071067811865475
Fx14_a1 0 x14_a1 V1 3.5355339059327378
Rp14_a1 0 x14_a1 7.766332233640755e-12
Cx15_a1 x15_a1 0 1.0
Gx15_a1 0 x15_a1 p1 0 0.07071067811865475
Fx15_a1 0 x15_a1 V1 3.5355339059327378
Rp15_a1 0 x15_a1 1.8095221673439617e-11
Cx16_re_a1 x16_re_a1 0 1.0
Gx16_re_a1 0 x16_re_a1 p1 0 0.1414213562373095
Fx16_re_a1 0 x16_re_a1 V1 7.0710678118654755
Rp16_re_re_a1 0 x16_re_a1 1.1460445945124401e-10
Gp16_re_im_a1 0 x16_re_a1 x16_im_a1 0 3105731083.7159095
Cx16_im_a1 x16_im_a1 0 1.0
Gp16_im_re_a1 0 x16_im_a1 x16_re_a1 0 -3105731083.7159095
Rp16_im_im_a1 0 x16_im_a1 1.1460445945124401e-10
*
* Port network for port 2
V2 p2 s2 0
R2 s2 0 50.0
Gd2_1 0 s2 p1 0 3.5294146189190906e-07
Fd2_1 0 s2 V1 1.7647073094595456e-05
Gr1_2_1 0 s2 x1_a1 0 -1154884288886.7158
Gr2_re_2_1 0 s2 x2_re_a1 0 -181800030582.03745
Gr2_im_2_1 0 s2 x2_im_a1 0 -175133520566.19095
Gr3_re_2_1 0 s2 x3_re_a1 0 -35198650960.580315
Gr3_im_2_1 0 s2 x3_im_a1 0 -19842952016.696278
Gr4_re_2_1 0 s2 x4_re_a1 0 -57235767324.71234
Gr4_im_2_1 0 s2 x4_im_a1 0 408164148169.1869
Gr5_re_2_1 0 s2 x5_re_a1 0 2528731510834.0703
Gr5_im_2_1 0 s2 x5_im_a1 0 -684997480055.4072
Gr6_re_2_1 0 s2 x6_re_a1 0 -20862855445.613743
Gr6_im_2_1 0 s2 x6_im_a1 0 17447475053.335384
Gr7_re_2_1 0 s2 x7_re_a1 0 -215597294.93321243
Gr7_im_2_1 0 s2 x7_im_a1 0 43740363.41425024
Gr8_2_1 0 s2 x8_a1 0 -24983864422799.707
Gr9_re_2_1 0 s2 x9_re_a1 0 -119199542927.74516
Gr9_im_2_1 0 s2 x9_im_a1 0 1073074539913.3654
Gr10_2_1 0 s2 x10_a1 0 24027061368984.523
Gr11_2_1 0 s2 x11_a1 0 -2824279611687.05
Gr12_2_1 0 s2 x12_a1 0 575062049399.9554
Gr13_re_2_1 0 s2 x13_re_a1 0 -8602593150.561441
Gr13_im_2_1 0 s2 x13_im_a1 0 -3151399447.4091406
Gr14_2_1 0 s2 x14_a1 0 -46038051459.32894
Gr15_2_1 0 s2 x15_a1 0 3414384881.446585
Gr16_re_2_1 0 s2 x16_re_a1 0 -55624453.602981605
Gr16_im_2_1 0 s2 x16_im_a1 0 -32237356.08090904
Gd2_2 0 s2 p2 0 8.86320844577515e-07
Fd2_2 0 s2 V2 4.431604222887575e-05
Gr1_2_2 0 s2 x1_a2 0 -6152029692344.37
Gr2_re_2_2 0 s2 x2_re_a2 0 -103852931316.19962
Gr2_im_2_2 0 s2 x2_im_a2 0 426592717907.59937
Gr3_re_2_2 0 s2 x3_re_a2 0 960874591.8682908
Gr3_im_2_2 0 s2 x3_im_a2 0 -34199045242.488873
Gr4_re_2_2 0 s2 x4_re_a2 0 30583826511.10379
Gr4_im_2_2 0 s2 x4_im_a2 0 280709036803.7568
Gr5_re_2_2 0 s2 x5_re_a2 0 2899557894968.0835
Gr5_im_2_2 0 s2 x5_im_a2 0 597854389644.6112
Gr6_re_2_2 0 s2 x6_re_a2 0 -3227239467.9814115
Gr6_im_2_2 0 s2 x6_im_a2 0 23256041412.840866
Gr7_re_2_2 0 s2 x7_re_a2 0 -191761092.8318743
Gr7_im_2_2 0 s2 x7_im_a2 0 17626611.446257982
Gr8_2_2 0 s2 x8_a2 0 -15459317175938.328
Gr9_re_2_2 0 s2 x9_re_a2 0 43411620067.815506
Gr9_im_2_2 0 s2 x9_im_a2 0 792231180422.4937
Gr10_2_2 0 s2 x10_a2 0 16116689829712.094
Gr11_2_2 0 s2 x11_a2 0 -2202562305891.2036
Gr12_2_2 0 s2 x12_a2 0 424013726506.3444
Gr13_re_2_2 0 s2 x13_re_a2 0 -6504377945.292516
Gr13_im_2_2 0 s2 x13_im_a2 0 -2221969631.5604687
Gr14_2_2 0 s2 x14_a2 0 -34577966187.901665
Gr15_2_2 0 s2 x15_a2 0 2373946550.6923122
Gr16_re_2_2 0 s2 x16_re_a2 0 -35553181.35202311
Gr16_im_2_2 0 s2 x16_im_a2 0 2295392.9647348835
Gd2_3 0 s2 p3 0 9.169092963967618e-07
Fd2_3 0 s2 V3 4.584546481983809e-05
Gr1_2_3 0 s2 x1_a3 0 -291157097895.7631
Gr2_re_2_3 0 s2 x2_re_a3 0 88950486101.6256
Gr2_im_2_3 0 s2 x2_im_a3 0 66405613482.086655
Gr3_re_2_3 0 s2 x3_re_a3 0 3404798142.3364067
Gr3_im_2_3 0 s2 x3_im_a3 0 -8338048933.524228
Gr4_re_2_3 0 s2 x4_re_a3 0 -36579348683.96941
Gr4_im_2_3 0 s2 x4_im_a3 0 10906079452.658445
Gr5_re_2_3 0 s2 x5_re_a3 0 -249229898813.51627
Gr5_im_2_3 0 s2 x5_im_a3 0 160195176536.32663
Gr6_re_2_3 0 s2 x6_re_a3 0 -14144833221.879025
Gr6_im_2_3 0 s2 x6_im_a3 0 20164663628.284412
Gr7_re_2_3 0 s2 x7_re_a3 0 -3202113.68233638
Gr7_im_2_3 0 s2 x7_im_a3 0 -11651609.462273616
Gr8_2_3 0 s2 x8_a3 0 2099543466986.452
Gr9_re_2_3 0 s2 x9_re_a3 0 27952177589.1539
Gr9_im_2_3 0 s2 x9_im_a3 0 -91180411842.85936
Gr10_2_3 0 s2 x10_a3 0 -1676742225092.093
Gr11_2_3 0 s2 x11_a3 0 194155288502.64667
Gr12_2_3 0 s2 x12_a3 0 -24962645105.921204
Gr13_re_2_3 0 s2 x13_re_a3 0 351358914.5549723
Gr13_im_2_3 0 s2 x13_im_a3 0 231444857.02884373
Gr14_2_3 0 s2 x14_a3 0 2875477044.2059336
Gr15_2_3 0 s2 x15_a3 0 -275835945.5306769
Gr16_re_2_3 0 s2 x16_re_a3 0 12502202.158458835
Gr16_im_2_3 0 s2 x16_im_a3 0 50835288.10979153
Gd2_4 0 s2 p4 0 8.910094778113996e-07
Fd2_4 0 s2 V4 4.4550473890569986e-05
Gr1_2_4 0 s2 x1_a4 0 -302432050347.1091
Gr2_re_2_4 0 s2 x2_re_a4 0 87232978808.05302
Gr2_im_2_4 0 s2 x2_im_a4 0 65791701576.478775
Gr3_re_2_4 0 s2 x3_re_a4 0 3299504747.9687023
Gr3_im_2_4 0 s2 x3_im_a4 0 -8418351792.740518
Gr4_re_2_4 0 s2 x4_re_a4 0 -37303029154.26916
Gr4_im_2_4 0 s2 x4_im_a4 0 12841992830.263739
Gr5_re_2_4 0 s2 x5_re_a4 0 -239234195718.98648
Gr5_im_2_4 0 s2 x5_im_a4 0 164256167468.84662
Gr6_re_2_4 0 s2 x6_re_a4 0 -14175660317.784042
Gr6_im_2_4 0 s2 x6_im_a4 0 20183360263.743347
Gr7_re_2_4 0 s2 x7_re_a4 0 -3778637.032655227
Gr7_im_2_4 0 s2 x7_im_a4 0 -10398869.04253279
Gr8_2_4 0 s2 x8_a4 0 2020074692854.6497
Gr9_re_2_4 0 s2 x9_re_a4 0 26909812098.723377
Gr9_im_2_4 0 s2 x9_im_a4 0 -86417834586.61922
Gr10_2_4 0 s2 x10_a4 0 -1591090155913.2524
Gr11_2_4 0 s2 x11_a4 0 182520682136.3975
Gr12_2_4 0 s2 x12_a4 0 -22470839043.612896
Gr13_re_2_4 0 s2 x13_re_a4 0 313056921.9790297
Gr13_im_2_4 0 s2 x13_im_a4 0 218619409.4729165
Gr14_2_4 0 s2 x14_a4 0 2676639530.81038
Gr15_2_4 0 s2 x15_a4 0 -261408479.9457695
Gr16_re_2_4 0 s2 x16_re_a4 0 12294972.095694046
Gr16_im_2_4 0 s2 x16_im_a4 0 50825498.140619405
Gd2_5 0 s2 p5 0 -2.176806984241497e-07
Fd2_5 0 s2 V5 -1.0884034921207486e-05
Gr1_2_5 0 s2 x1_a5 0 38930547041.61987
Gr2_re_2_5 0 s2 x2_re_a5 0 -96405257576.16321
Gr2_im_2_5 0 s2 x2_im_a5 0 -290865458811.4969
Gr3_re_2_5 0 s2 x3_re_a5 0 67789865.37156196
Gr3_im_2_5 0 s2 x3_im_a5 0 -10839489037.080544
Gr4_re_2_5 0 s2 x4_re_a5 0 -170540238368.51437
Gr4_im_2_5 0 s2 x4_im_a5 0 -5620930559.323378
Gr5_re_2_5 0 s2 x5_re_a5 0 -296119184562.30023
Gr5_im_2_5 0 s2 x5_im_a5 0 1124337672544.1204
Gr6_re_2_5 0 s2 x6_re_a5 0 -5973701345.487456
Gr6_im_2_5 0 s2 x6_im_a5 0 15116241376.27323
Gr7_re_2_5 0 s2 x7_re_a5 0 8439191.519865254
Gr7_im_2_5 0 s2 x7_im_a5 0 -27426697.91541635
Gr8_2_5 0 s2 x8_a5 0 6472140233147.477
Gr9_re_2_5 0 s2 x9_re_a5 0 -220888930634.8215
Gr9_im_2_5 0 s2 x9_im_a5 0 -144328912471.20538
Gr10_2_5 0 s2 x10_a5 0 -5350715152759.486
Gr11_2_5 0 s2 x11_a5 0 637799095369.821
Gr12_2_5 0 s2 x12_a5 0 -91336238818.91072
Gr13_re_2_5 0 s2 x13_re_a5 0 1331866716.2164114
Gr13_im_2_5 0 s2 x13_im_a5 0 671988794.6051908
Gr14_2_5 0 s2 x14_a5 0 8846133113.039326
Gr15_2_5 0 s2 x15_a5 0 -735154242.5753922
Gr16_re_2_5 0 s2 x16_re_a5 0 22626762.62315765
Gr16_im_2_5 0 s2 x16_im_a5 0 52171059.1759973
Gd2_6 0 s2 p6 0 7.748748111189446e-07
Fd2_6 0 s2 V6 3.874374055594723e-05
Gr1_2_6 0 s2 x1_a6 0 798644133551.8063
Gr2_re_2_6 0 s2 x2_re_a6 0 -74271710305.60652
Gr2_im_2_6 0 s2 x2_im_a6 0 131259702459.2447
Gr3_re_2_6 0 s2 x3_re_a6 0 -11040185016.512745
Gr3_im_2_6 0 s2 x3_im_a6 0 14893279296.656948
Gr4_re_2_6 0 s2 x4_re_a6 0 189695761336.89746
Gr4_im_2_6 0 s2 x4_im_a6 0 11676075443.106844
Gr5_re_2_6 0 s2 x5_re_a6 0 422790881899.9889
Gr5_im_2_6 0 s2 x5_im_a6 0 -951388960034.664
Gr6_re_2_6 0 s2 x6_re_a6 0 -12517529774.390863
Gr6_im_2_6 0 s2 x6_im_a6 0 12439555695.081573
Gr7_re_2_6 0 s2 x7_re_a6 0 -338720.6051687762
Gr7_im_2_6 0 s2 x7_im_a6 0 45244247.993294984
Gr8_2_6 0 s2 x8_a6 0 -7322422608812.219
Gr9_re_2_6 0 s2 x9_re_a6 0 213754742987.69888
Gr9_im_2_6 0 s2 x9_im_a6 0 358296647756.81213
Gr10_2_6 0 s2 x10_a6 0 5804222793184.31
Gr11_2_6 0 s2 x11_a6 0 -429503694944.69794
Gr12_2_6 0 s2 x12_a6 0 70969450021.36465
Gr13_re_2_6 0 s2 x13_re_a6 0 -781554570.0182092
Gr13_im_2_6 0 s2 x13_im_a6 0 -88203900.01017308
Gr14_2_6 0 s2 x14_a6 0 -4462305542.513927
Gr15_2_6 0 s2 x15_a6 0 392999324.83208555
Gr16_re_2_6 0 s2 x16_re_a6 0 -14656100.625072036
Gr16_im_2_6 0 s2 x16_im_a6 0 -51261894.349656574
Gd2_7 0 s2 p7 0 1.0298092696044147e-07
Fd2_7 0 s2 V7 5.149046348022074e-06
Gr1_2_7 0 s2 x1_a7 0 2565794702122.9053
Gr2_re_2_7 0 s2 x2_re_a7 0 -99014244020.8726
Gr2_im_2_7 0 s2 x2_im_a7 0 -72440109952.29385
Gr3_re_2_7 0 s2 x3_re_a7 0 2137886520.0023065
Gr3_im_2_7 0 s2 x3_im_a7 0 10055744822.570215
Gr4_re_2_7 0 s2 x4_re_a7 0 12687344976.438847
Gr4_im_2_7 0 s2 x4_im_a7 0 -46680756226.87015
Gr5_re_2_7 0 s2 x5_re_a7 0 -707454569595.2571
Gr5_im_2_7 0 s2 x5_im_a7 0 -128415280160.52939
Gr6_re_2_7 0 s2 x6_re_a7 0 -16021474871.845192
Gr6_im_2_7 0 s2 x6_im_a7 0 15491733042.509916
Gr7_re_2_7 0 s2 x7_re_a7 0 44047485.44598047
Gr7_im_2_7 0 s2 x7_im_a7 0 -8922424.253168138
Gr8_2_7 0 s2 x8_a7 0 4430846801623.035
Gr9_re_2_7 0 s2 x9_re_a7 0 -42954610835.674706
Gr9_im_2_7 0 s2 x9_im_a7 0 -208268269641.87582
Gr10_2_7 0 s2 x10_a7 0 -4366058687153.233
Gr11_2_7 0 s2 x11_a7 0 458833666459.1986
Gr12_2_7 0 s2 x12_a7 0 -104061557033.50711
Gr13_re_2_7 0 s2 x13_re_a7 0 1486390719.0989087
Gr13_im_2_7 0 s2 x13_im_a7 0 490807686.50025535
Gr14_2_7 0 s2 x14_a7 0 7732086874.494483
Gr15_2_7 0 s2 x15_a7 0 -617010169.4315357
Gr16_re_2_7 0 s2 x16_re_a7 0 12352222.286206083
Gr16_im_2_7 0 s2 x16_im_a7 0 10448961.581161974
Gd2_8 0 s2 p8 0 1.1102117827756913e-08
Fd2_8 0 s2 V8 5.551058913878457e-07
Gr1_2_8 0 s2 x1_a8 0 2560130709088.8228
Gr2_re_2_8 0 s2 x2_re_a8 0 -98864640824.24628
Gr2_im_2_8 0 s2 x2_im_a8 0 -70835812828.90329
Gr3_re_2_8 0 s2 x3_re_a8 0 2563818915.119373
Gr3_im_2_8 0 s2 x3_im_a8 0 10229080606.920729
Gr4_re_2_8 0 s2 x4_re_a8 0 13221726401.952711
Gr4_im_2_8 0 s2 x4_im_a8 0 -48510845183.746994
Gr5_re_2_8 0 s2 x5_re_a8 0 -710984309733.6598
Gr5_im_2_8 0 s2 x5_im_a8 0 -125087990132.01494
Gr6_re_2_8 0 s2 x6_re_a8 0 -16023325756.626545
Gr6_im_2_8 0 s2 x6_im_a8 0 15461444861.59086
Gr7_re_2_8 0 s2 x7_re_a8 0 44740681.24352438
Gr7_im_2_8 0 s2 x7_im_a8 0 -7986205.928009006
Gr8_2_8 0 s2 x8_a8 0 4489069346948.64
Gr9_re_2_8 0 s2 x9_re_a8 0 -43009768283.46571
Gr9_im_2_8 0 s2 x9_im_a8 0 -210640447013.07996
Gr10_2_8 0 s2 x10_a8 0 -4419570309370.745
Gr11_2_8 0 s2 x11_a8 0 465072082416.2315
Gr12_2_8 0 s2 x12_a8 0 -105387418548.11153
Gr13_re_2_8 0 s2 x13_re_a8 0 1505908947.3472044
Gr13_im_2_8 0 s2 x13_im_a8 0 499037862.68322384
Gr14_2_8 0 s2 x14_a8 0 7845224639.407399
Gr15_2_8 0 s2 x15_a8 0 -626750297.4508358
Gr16_re_2_8 0 s2 x16_re_a8 0 12569340.05532933
Gr16_im_2_8 0 s2 x16_im_a8 0 10856119.168150283
*
* State networks driven by port 2
Cx1_a2 x1_a2 0 1.0
Gx1_a2 0 x1_a2 p2 0 0.07071067811865475
Fx1_a2 0 x1_a2 V2 3.5355339059327378
Rp1_a2 0 x1_a2 1.2667707539388034e-13
Cx2_re_a2 x2_re_a2 0 1.0
Gx2_re_a2 0 x2_re_a2 p2 0 0.1414213562373095
Fx2_re_a2 0 x2_re_a2 V2 7.0710678118654755
Rp2_re_re_a2 0 x2_re_a2 9.289804648696368e-13
Gp2_re_im_a2 0 x2_re_a2 x2_im_a2 0 3958398257259.3657
Cx2_im_a2 x2_im_a2 0 1.0
Gp2_im_re_a2 0 x2_im_a2 x2_re_a2 0 -3958398257259.3657
Rp2_im_im_a2 0 x2_im_a2 9.289804648696368e-13
Cx3_re_a2 x3_re_a2 0 1.0
Gx3_re_a2 0 x3_re_a2 p2 0 0.1414213562373095
Fx3_re_a2 0 x3_re_a2 V2 7.0710678118654755
Rp3_re_re_a2 0 x3_re_a2 1.8873881915204676e-12
Gp3_re_im_a2 0 x3_re_a2 x3_im_a2 0 3441166588437.5947
Cx3_im_a2 x3_im_a2 0 1.0
Gp3_im_re_a2 0 x3_im_a2 x3_re_a2 0 -3441166588437.5947
Rp3_im_im_a2 0 x3_im_a2 1.8873881915204676e-12
Cx4_re_a2 x4_re_a2 0 1.0
Gx4_re_a2 0 x4_re_a2 p2 0 0.1414213562373095
Fx4_re_a2 0 x4_re_a2 V2 7.0710678118654755
Rp4_re_re_a2 0 x4_re_a2 9.922592044099783e-13
Gp4_re_im_a2 0 x4_re_a2 x4_im_a2 0 3220889250610.056
Cx4_im_a2 x4_im_a2 0 1.0
Gp4_im_re_a2 0 x4_im_a2 x4_re_a2 0 -3220889250610.056
Rp4_im_im_a2 0 x4_im_a2 9.922592044099783e-13
Cx5_re_a2 x5_re_a2 0 1.0
Gx5_re_a2 0 x5_re_a2 p2 0 0.1414213562373095
Fx5_re_a2 0 x5_re_a2 V2 7.0710678118654755
Rp5_re_re_a2 0 x5_re_a2 4.2837375484112484e-13
Gp5_re_im_a2 0 x5_re_a2 x5_im_a2 0 2073506969966.306
Cx5_im_a2 x5_im_a2 0 1.0
Gp5_im_re_a2 0 x5_im_a2 x5_re_a2 0 -2073506969966.306
Rp5_im_im_a2 0 x5_im_a2 4.2837375484112484e-13
Cx6_re_a2 x6_re_a2 0 1.0
Gx6_re_a2 0 x6_re_a2 p2 0 0.1414213562373095
Fx6_re_a2 0 x6_re_a2 V2 7.0710678118654755
Rp6_re_re_a2 0 x6_re_a2 2.8457065637511862e-12
Gp6_re_im_a2 0 x6_re_a2 x6_im_a2 0 2302996887167.347
Cx6_im_a2 x6_im_a2 0 1.0
Gp6_im_re_a2 0 x6_im_a2 x6_re_a2 0 -2302996887167.347
Rp6_im_im_a2 0 x6_im_a2 2.8457065637511862e-12
Cx7_re_a2 x7_re_a2 0 1.0
Gx7_re_a2 0 x7_re_a2 p2 0 0.1414213562373095
Fx7_re_a2 0 x7_re_a2 V2 7.0710678118654755
Rp7_re_re_a2 0 x7_re_a2 1.764884203986438e-11
Gp7_re_im_a2 0 x7_re_a2 x7_im_a2 0 1893361683671.1223
Cx7_im_a2 x7_im_a2 0 1.0
Gp7_im_re_a2 0 x7_im_a2 x7_re_a2 0 -1893361683671.1223
Rp7_im_im_a2 0 x7_im_a2 1.764884203986438e-11
Cx8_a2 x8_a2 0 1.0
Gx8_a2 0 x8_a2 p2 0 0.07071067811865475
Fx8_a2 0 x8_a2 V2 3.5355339059327378
Rp8_a2 0 x8_a2 7.134017483278191e-13
Cx9_re_a2 x9_re_a2 0 1.0
Gx9_re_a2 0 x9_re_a2 p2 0 0.1414213562373095
Fx9_re_a2 0 x9_re_a2 V2 7.0710678118654755
Rp9_re_re_a2 0 x9_re_a2 1.1810108382102504e-12
Gp9_re_im_a2 0 x9_re_a2 x9_im_a2 0 667262162732.5848
Cx9_im_a2 x9_im_a2 0 1.0
Gp9_im_re_a2 0 x9_im_a2 x9_re_a2 0 -667262162732.5848
Rp9_im_im_a2 0 x9_im_a2 1.1810108382102504e-12
Cx10_a2 x10_a2 0 1.0
Gx10_a2 0 x10_a2 p2 0 0.07071067811865475
Fx10_a2 0 x10_a2 V2 3.5355339059327378
Rp10_a2 0 x10_a2 9.059895014373575e-13
Cx11_a2 x11_a2 0 1.0
Gx11_a2 0 x11_a2 p2 0 0.07071067811865475
Fx11_a2 0 x11_a2 V2 3.5355339059327378
Rp11_a2 0 x11_a2 1.7461165062812219e-12
Cx12_a2 x12_a2 0 1.0
Gx12_a2 0 x12_a2 p2 0 0.07071067811865475
Fx12_a2 0 x12_a2 V2 3.5355339059327378
Rp12_a2 0 x12_a2 2.9716792303835088e-12
Cx13_re_a2 x13_re_a2 0 1.0
Gx13_re_a2 0 x13_re_a2 p2 0 0.1414213562373095
Fx13_re_a2 0 x13_re_a2 V2 7.0710678118654755
Rp13_re_re_a2 0 x13_re_a2 8.809235095423119e-12
Gp13_re_im_a2 0 x13_re_a2 x13_im_a2 0 123160380596.87326
Cx13_im_a2 x13_im_a2 0 1.0
Gp13_im_re_a2 0 x13_im_a2 x13_re_a2 0 -123160380596.87326
Rp13_im_im_a2 0 x13_im_a2 8.809235095423119e-12
Cx14_a2 x14_a2 0 1.0
Gx14_a2 0 x14_a2 p2 0 0.07071067811865475
Fx14_a2 0 x14_a2 V2 3.5355339059327378
Rp14_a2 0 x14_a2 7.766332233640755e-12
Cx15_a2 x15_a2 0 1.0
Gx15_a2 0 x15_a2 p2 0 0.07071067811865475
Fx15_a2 0 x15_a2 V2 3.5355339059327378
Rp15_a2 0 x15_a2 1.8095221673439617e-11
Cx16_re_a2 x16_re_a2 0 1.0
Gx16_re_a2 0 x16_re_a2 p2 0 0.1414213562373095
Fx16_re_a2 0 x16_re_a2 V2 7.0710678118654755
Rp16_re_re_a2 0 x16_re_a2 1.1460445945124401e-10
Gp16_re_im_a2 0 x16_re_a2 x16_im_a2 0 3105731083.7159095
Cx16_im_a2 x16_im_a2 0 1.0
Gp16_im_re_a2 0 x16_im_a2 x16_re_a2 0 -3105731083.7159095
Rp16_im_im_a2 0 x16_im_a2 1.1460445945124401e-10
*
* Port network for port 3
V3 p3 s3 0
R3 s3 0 50.0
Gd3_1 0 s3 p1 0 5.627358263815552e-07
Fd3_1 0 s3 V1 2.813679131907776e-05
Gr1_3_1 0 s3 x1_a1 0 560462634403.13
Gr2_re_3_1 0 s3 x2_re_a1 0 13174439905.739363
Gr2_im_3_1 0 s3 x2_im_a1 0 -62726887733.59619
Gr3_re_3_1 0 s3 x3_re_a1 0 -16609700104.731373
Gr3_im_3_1 0 s3 x3_im_a1 0 -12351821516.13931
Gr4_re_3_1 0 s3 x4_re_a1 0 -141848921494.90207
Gr4_im_3_1 0 s3 x4_im_a1 0 5419877440.855587
Gr5_re_3_1 0 s3 x5_re_a1 0 -152697757960.04913
Gr5_im_3_1 0 s3 x5_im_a1 0 470803571021.25385
Gr6_re_3_1 0 s3 x6_re_a1 0 -27250499349.77613
Gr6_im_3_1 0 s3 x6_im_a1 0 -1932243595.3618693
Gr7_re_3_1 0 s3 x7_re_a1 0 -23290332.14303995
Gr7_im_3_1 0 s3 x7_im_a1 0 -22074805.795875337
Gr8_3_1 0 s3 x8_a1 0 2067414031864.4111
Gr9_re_3_1 0 s3 x9_re_a1 0 -94577617325.51785
Gr9_im_3_1 0 s3 x9_im_a1 0 -82115092801.70107
Gr10_3_1 0 s3 x10_a1 0 -1284756416023.3635
Gr11_3_1 0 s3 x11_a1 0 36437661963.24908
Gr12_3_1 0 s3 x12_a1 0 2220896781.642778
Gr13_re_3_1 0 s3 x13_re_a1 0 -183848247.80387172
Gr13_im_3_1 0 s3 x13_im_a1 0 49903700.50611038
Gr14_3_1 0 s3 x14_a1 0 203603342.98853254
Gr15_3_1 0 s3 x15_a1 0 -185221656.34248385
Gr16_re_3_1 0 s3 x16_re_a1 0 14611079.010466557
Gr16_im_3_1 0 s3 x16_im_a1 0 70270585.96131554
Gd3_2 0 s3 p2 0 9.169092963967618e-07
Fd3_2 0 s3 V2 4.584546481983809e-05
Gr1_3_2 0 s3 x1_a2 0 -291157097895.7575
Gr2_re_3_2 0 s3 x2_re_a2 0 88950486101.6261
Gr2_im_3_2 0 s3 x2_im_a2 0 66405613482.08653
Gr3_re_3_2 0 s3 x3_re_a2 0 3404798142.336475
Gr3_im_3_2 0 s3 x3_im_a2 0 -8338048933.524219
Gr4_re_3_2 0 s3 x4_re_a2 0 -36579348683.96957
Gr4_im_3_2 0 s3 x4_im_a2 0 10906079452.658154
Gr5_re_3_2 0 s3 x5_re_a2 0 -249229898813.51636
Gr5_im_3_2 0 s3 x5_im_a2 0 160195176536.32373
Gr6_re_3_2 0 s3 x6_re_a2 0 -14144833221.879017
Gr6_im_3_2 0 s3 x6_im_a2 0 20164663628.28443
Gr7_re_3_2 0 s3 x7_re_a2 0 -3202113.6823377064
Gr7_im_3_2 0 s3 x7_im_a2 0 -11651609.462275535
Gr8_3_2 0 s3 x8_a2 0 2099543466986.4329
Gr9_re_3_2 0 s3 x9_re_a2 0 27952177589.155556
Gr9_im_3_2 0 s3 x9_im_a2 0 -91180411842.85782
Gr10_3_2 0 s3 x10_a2 0 -1676742225092.084
Gr11_3_2 0 s3 x11_a2 0 194155288502.65244
Gr12_3_2 0 s3 x12_a2 0 -24962645105.924046
Gr13_re_3_2 0 s3 x13_re_a2 0 351358914.5550141
Gr13_im_3_2 0 s3 x13_im_a2 0 231444857.02892283
Gr14_3_2 0 s3 x14_a2 0 2875477044.2064843
Gr15_3_2 0 s3 x15_a2 0 -275835945.5307226
Gr16_re_3_2 0 s3 x16_re_a2 0 12502202.15845744
Gr16_im_3_2 0 s3 x16_im_a2 0 50835288.10979699
Gd3_3 0 s3 p3 0 2.9117439802162083e-07
Fd3_3 0 s3 V3 1.4558719901081043e-05
Gr1_3_3 0 s3 x1_a3 0 -5869659385111.593
Gr2_re_3_3 0 s3 x2_re_a3 0 2796650426.76875
Gr2_im_3_3 0 s3 x2_im_a3 0 281701490858.79456
Gr3_re_3_3 0 s3 x3_re_a3 0 52595320618.52092
Gr3_im_3_3 0 s3 x3_im_a3 0 69234041013.60457
Gr4_re_3_3 0 s3 x4_re_a3 0 124605075161.70279
Gr4_im_3_3 0 s3 x4_im_a3 0 201283500939.76556
Gr5_re_3_3 0 s3 x5_re_a3 0 1497380917570.674
Gr5_im_3_3 0 s3 x5_im_a3 0 -250925971590.1522
Gr6_re_3_3 0 s3 x6_re_a3 0 -30901214837.488567
Gr6_im_3_3 0 s3 x6_im_a3 0 9321909868.922115
Gr7_re_3_3 0 s3 x7_re_a3 0 -2871777678.684842
Gr7_im_3_3 0 s3 x7_im_a3 0 976399394.5494903
Gr8_3_3 0 s3 x8_a3 0 4016753791722.328
Gr9_re_3_3 0 s3 x9_re_a3 0 -39959705867.99739
Gr9_im_3_3 0 s3 x9_im_a3 0 -98729441163.98325
Gr10_3_3 0 s3 x10_a3 0 -3198461400319.5166
Gr11_3_3 0 s3 x11_a3 0 83185740874.27982
Gr12_3_3 0 s3 x12_a3 0 -42600699917.4218
Gr13_re_3_3 0 s3 x13_re_a3 0 457894462.17127436
Gr13_im_3_3 0 s3 x13_im_a3 0 174387544.91475192
Gr14_3_3 0 s3 x14_a3 0 2183935951.4768915
Gr15_3_3 0 s3 x15_a3 0 -338621794.71482706
Gr16_re_3_3 0 s3 x16_re_a3 0 4062651.470347851
Gr16_im_3_3 0 s3 x16_im_a3 0 22198672.52823676
Gd3_4 0 s3 p4 0 9.034609455116361e-07
Fd3_4 0 s3 V4 4.51730472755818e-05
Gr1_3_4 0 s3 x1_a4 0 987985177298.0359
Gr2_re_3_4 0 s3 x2_re_a4 0 82928783277.42113
Gr2_im_3_4 0 s3 x2_im_a4 0 -127599433148.23581
Gr3_re_3_4 0 s3 x3_re_a4 0 -41282329683.58334
Gr3_im_3_4 0 s3 x3_im_a4 0 -70019551142.43416
Gr4_re_3_4 0 s3 x4_re_a4 0 -100043534931.79245
Gr4_im_3_4 0 s3 x4_im_a4 0 -295668837143.43
Gr5_re_3_4 0 s3 x5_re_a4 0 -396539600438.192
Gr5_im_3_4 0 s3 x5_im_a4 0 1457074521560.2588
Gr6_re_3_4 0 s3 x6_re_a4 0 -31113104490.10292
Gr6_im_3_4 0 s3 x6_im_a4 0 9181142787.684956
Gr7_re_3_4 0 s3 x7_re_a4 0 2879925053.629542
Gr7_im_3_4 0 s3 x7_im_a4 0 -987310567.2909907
Gr8_3_4 0 s3 x8_a4 0 1380478835563.2112
Gr9_re_3_4 0 s3 x9_re_a4 0 19152550869.703865
Gr9_im_3_4 0 s3 x9_im_a4 0 -56822700113.084496
Gr10_3_4 0 s3 x10_a4 0 -928151273299.9976
Gr11_3_4 0 s3 x11_a4 0 223233626465.3763
Gr12_3_4 0 s3 x12_a4 0 -23390443687.15211
Gr13_re_3_4 0 s3 x13_re_a4 0 396736158.97386074
Gr13_im_3_4 0 s3 x13_im_a4 0 175469773.0109653
Gr14_3_4 0 s3 x14_a4 0 2674598612.6931815
Gr15_3_4 0 s3 x15_a4 0 -152152157.09571925
Gr16_re_3_4 0 s3 x16_re_a4 0 10542978.606948419
Gr16_im_3_4 0 s3 x16_im_a4 0 23183120.028712906
Gd3_5 0 s3 p5 0 -7.393551031324372e-08
Fd3_5 0 s3 V5 -3.6967755156621864e-06
Gr1_3_5 0 s3 x1_a5 0 2592963047181.0693
Gr2_re_3_5 0 s3 x2_re_a5 0 -78207296514.99577
Gr2_im_3_5 0 s3 x2_im_a5 0 -104285949431.16267
Gr3_re_3_5 0 s3 x3_re_a5 0 2148919321.398183
Gr3_im_3_5 0 s3 x3_im_a5 0 5016138989.380752
Gr4_re_3_5 0 s3 x4_re_a5 0 -36328567170.18967
Gr4_im_3_5 0 s3 x4_im_a5 0 -46191938014.134834
Gr5_re_3_5 0 s3 x5_re_a5 0 -745985163710.4219
Gr5_im_3_5 0 s3 x5_im_a5 0 10998918928.47653
Gr6_re_3_5 0 s3 x6_re_a5 0 -18130891407.427258
Gr6_im_3_5 0 s3 x6_im_a5 0 10873759134.899137
Gr7_re_3_5 0 s3 x7_re_a5 0 39329673.479137756
Gr7_im_3_5 0 s3 x7_im_a5 0 -13772704.611227863
Gr8_3_5 0 s3 x8_a5 0 5152329635144.931
Gr9_re_3_5 0 s3 x9_re_a5 0 -61189758715.92409
Gr9_im_3_5 0 s3 x9_im_a5 0 -227272401035.2738
Gr10_3_5 0 s3 x10_a5 0 -4937662294949.198
Gr11_3_5 0 s3 x11_a5 0 511800948403.68097
Gr12_3_5 0 s3 x12_a5 0 -115358679915.69194
Gr13_re_3_5 0 s3 x13_re_a5 0 1674926626.6234763
Gr13_im_3_5 0 s3 x13_im_a5 0 643008655.2826424
Gr14_3_5 0 s3 x14_a5 0 9030523505.395348
Gr15_3_5 0 s3 x15_a5 0 -726319235.8375545
Gr16_re_3_5 0 s3 x16_re_a5 0 14012555.07543086
Gr16_im_3_5 0 s3 x16_im_a5 0 18752186.826970905
Gd3_6 0 s3 p6 0 2.520605077149102e-07
Fd3_6 0 s3 V6 1.2603025385745509e-05
Gr1_3_6 0 s3 x1_a6 0 1016461980295.8627
Gr2_re_3_6 0 s3 x2_re_a6 0 -12788566028.612701
Gr2_im_3_6 0 s3 x2_im_a6 0 4577133261.130653
Gr3_re_3_6 0 s3 x3_re_a6 0 13538622872.093721
Gr3_im_3_6 0 s3 x3_im_a6 0 15426118849.079397
Gr4_re_3_6 0 s3 x4_re_a6 0 139131352076.33783
Gr4_im_3_6 0 s3 x4_im_a6 0 32511809950.833405
Gr5_re_3_6 0 s3 x5_re_a6 0 -164733629214.15195
Gr5_im_3_6 0 s3 x5_im_a6 0 -809227828499.9589
Gr6_re_3_6 0 s3 x6_re_a6 0 -22116985881.098003
Gr6_im_3_6 0 s3 x6_im_a6 0 -107138404.05810504
Gr7_re_3_6 0 s3 x7_re_a6 0 16993569.496352494
Gr7_im_3_6 0 s3 x7_im_a6 0 20215231.18632604
Gr8_3_6 0 s3 x8_a6 0 -2630768065431.766
Gr9_re_3_6 0 s3 x9_re_a6 0 96682407023.29755
Gr9_im_3_6 0 s3 x9_im_a6 0 98686605074.87791
Gr10_3_6 0 s3 x10_a6 0 1752713053253.136
Gr11_3_6 0 s3 x11_a6 0 -81525465953.68048
Gr12_3_6 0 s3 x12_a6 0 5813738135.968654
Gr13_re_3_6 0 s3 x13_re_a6 0 59044586.81375218
Gr13_im_3_6 0 s3 x13_im_a6 0 37673522.635623164
Gr14_3_6 0 s3 x14_a6 0 -100016938.32366918
Gr15_3_6 0 s3 x15_a6 0 89953623.32324515
Gr16_re_3_6 0 s3 x16_re_a6 0 -5088851.101875612
Gr16_im_3_6 0 s3 x16_im_a6 0 -33705986.269606486
Gd3_7 0 s3 p7 0 2.5803729011871295e-07
Fd3_7 0 s3 V7 1.2901864505935647e-05
Gr1_3_7 0 s3 x1_a7 0 591051369485.704
Gr2_re_3_7 0 s3 x2_re_a7 0 -55839924507.587135
Gr2_im_3_7 0 s3 x2_im_a7 0 -89523374528.01134
Gr3_re_3_7 0 s3 x3_re_a7 0 -26245406596.282154
Gr3_im_3_7 0 s3 x3_im_a7 0 107214973950.16727
Gr4_re_3_7 0 s3 x4_re_a7 0 -16530672120.49258
Gr4_im_3_7 0 s3 x4_im_a7 0 -293603296070.7177
Gr5_re_3_7 0 s3 x5_re_a7 0 472284930041.1455
Gr5_im_3_7 0 s3 x5_im_a7 0 21287782175.096935
Gr6_re_3_7 0 s3 x6_re_a7 0 -31166404636.823746
Gr6_im_3_7 0 s3 x6_im_a7 0 3178304015.833087
Gr7_re_3_7 0 s3 x7_re_a7 0 -3060881490.0539894
Gr7_im_3_7 0 s3 x7_im_a7 0 227145277.6240401
Gr8_3_7 0 s3 x8_a7 0 -3564673055614.252
Gr9_re_3_7 0 s3 x9_re_a7 0 10822963966.011333
Gr9_im_3_7 0 s3 x9_im_a7 0 66440416793.97594
Gr10_3_7 0 s3 x10_a7 0 2377539706988.319
Gr11_3_7 0 s3 x11_a7 0 -27534367088.34659
Gr12_3_7 0 s3 x12_a7 0 30452880267.80134
Gr13_re_3_7 0 s3 x13_re_a7 0 -387618203.120587
Gr13_im_3_7 0 s3 x13_im_a7 0 -139561013.77670753
Gr14_3_7 0 s3 x14_a7 0 -1951192383.8952415
Gr15_3_7 0 s3 x15_a7 0 187265933.59484297
Gr16_re_3_7 0 s3 x16_re_a7 0 -694475.3334339135
Gr16_im_3_7 0 s3 x16_im_a7 0 -12405508.596839871
Gd3_8 0 s3 p8 0 1.6433308721537644e-07
Fd3_8 0 s3 V8 8.216654360768821e-06
Gr1_3_8 0 s3 x1_a8 0 -25642647858.07865
Gr2_re_3_8 0 s3 x2_re_a8 0 -120894774762.355
Gr2_im_3_8 0 s3 x2_im_a8 0 -119999899583.35008
Gr3_re_3_8 0 s3 x3_re_a8 0 24757606086.252098
Gr3_im_3_8 0 s3 x3_im_a8 0 -100412662986.14462
Gr4_re_3_8 0 s3 x4_re_a8 0 35422670257.841125
Gr4_im_3_8 0 s3 x4_im_a8 0 358344847936.76056
Gr5_re_3_8 0 s3 x5_re_a8 0 -123113944024.12234
Gr5_im_3_8 0 s3 x5_im_a8 0 55647360577.75043
Gr6_re_3_8 0 s3 x6_re_a8 0 -31157830236.442715
Gr6_im_3_8 0 s3 x6_im_a8 0 3101511481.338296
Gr7_re_3_8 0 s3 x7_re_a8 0 3053205050.981448
Gr7_im_3_8 0 s3 x7_im_a8 0 -210326031.13615158
Gr8_3_8 0 s3 x8_a8 0 227770884868.12607
Gr9_re_3_8 0 s3 x9_re_a8 0 -19290797739.287895
Gr9_im_3_8 0 s3 x9_im_a8 0 66724374743.52285
Gr10_3_8 0 s3 x10_a8 0 494403857803.11914
Gr11_3_8 0 s3 x11_a8 0 -214434959140.56558
Gr12_3_8 0 s3 x12_a8 0 24725003037.426697
Gr13_re_3_8 0 s3 x13_re_a8 0 -384283789.125427
Gr13_im_3_8 0 s3 x13_im_a8 0 -131132645.30071087
Gr14_3_8 0 s3 x14_a8 0 -2165745564.350239
Gr15_3_8 0 s3 x15_a8 0 148201124.11891955
Gr16_re_3_8 0 s3 x16_re_a8 0 -6216478.735597659
Gr16_im_3_8 0 s3 x16_im_a8 0 -12544197.258885413
*
* State networks driven by port 3
Cx1_a3 x1_a3 0 1.0
Gx1_a3 0 x1_a3 p3 0 0.07071067811865475
Fx1_a3 0 x1_a3 V3 3.5355339059327378
Rp1_a3 0 x1_a3 1.2667707539388034e-13
Cx2_re_a3 x2_re_a3 0 1.0
Gx2_re_a3 0 x2_re_a3 p3 0 0.1414213562373095
Fx2_re_a3 0 x2_re_a3 V3 7.0710678118654755
Rp2_re_re_a3 0 x2_re_a3 9.289804648696368e-13
Gp2_re_im_a3 0 x2_re_a3 x2_im_a3 0 3958398257259.3657
Cx2_im_a3 x2_im_a3 0 1.0
Gp2_im_re_a3 0 x2_im_a3 x2_re_a3 0 -3958398257259.3657
Rp2_im_im_a3 0 x2_im_a3 9.289804648696368e-13
Cx3_re_a3 x3_re_a3 0 1.0
Gx3_re_a3 0 x3_re_a3 p3 0 0.1414213562373095
Fx3_re_a3 0 x3_re_a3 V3 7.0710678118654755
Rp3_re_re_a3 0 x3_re_a3 1.8873881915204676e-12
Gp3_re_im_a3 0 x3_re_a3 x3_im_a3 0 3441166588437.5947
Cx3_im_a3 x3_im_a3 0 1.0
Gp3_im_re_a3 0 x3_im_a3 x3_re_a3 0 -3441166588437.5947
Rp3_im_im_a3 0 x3_im_a3 1.8873881915204676e-12
Cx4_re_a3 x4_re_a3 0 1.0
Gx4_re_a3 0 x4_re_a3 p3 0 0.1414213562373095
Fx4_re_a3 0 x4_re_a3 V3 7.0710678118654755
Rp4_re_re_a3 0 x4_re_a3 9.922592044099783e-13
Gp4_re_im_a3 0 x4_re_a3 x4_im_a3 0 3220889250610.056
Cx4_im_a3 x4_im_a3 0 1.0
Gp4_im_re_a3 0 x4_im_a3 x4_re_a3 0 -3220889250610.056
Rp4_im_im_a3 0 x4_im_a3 9.922592044099783e-13
Cx5_re_a3 x5_re_a3 0 1.0
Gx5_re_a3 0 x5_re_a3 p3 0 0.1414213562373095
Fx5_re_a3 0 x5_re_a3 V3 7.0710678118654755
Rp5_re_re_a3 0 x5_re_a3 4.2837375484112484e-13
Gp5_re_im_a3 0 x5_re_a3 x5_im_a3 0 2073506969966.306
Cx5_im_a3 x5_im_a3 0 1.0
Gp5_im_re_a3 0 x5_im_a3 x5_re_a3 0 -2073506969966.306
Rp5_im_im_a3 0 x5_im_a3 4.2837375484112484e-13
Cx6_re_a3 x6_re_a3 0 1.0
Gx6_re_a3 0 x6_re_a3 p3 0 0.1414213562373095
Fx6_re_a3 0 x6_re_a3 V3 7.0710678118654755
Rp6_re_re_a3 0 x6_re_a3 2.8457065637511862e-12
Gp6_re_im_a3 0 x6_re_a3 x6_im_a3 0 2302996887167.347
Cx6_im_a3 x6_im_a3 0 1.0
Gp6_im_re_a3 0 x6_im_a3 x6_re_a3 0 -2302996887167.347
Rp6_im_im_a3 0 x6_im_a3 2.8457065637511862e-12
Cx7_re_a3 x7_re_a3 0 1.0
Gx7_re_a3 0 x7_re_a3 p3 0 0.1414213562373095
Fx7_re_a3 0 x7_re_a3 V3 7.0710678118654755
Rp7_re_re_a3 0 x7_re_a3 1.764884203986438e-11
Gp7_re_im_a3 0 x7_re_a3 x7_im_a3 0 1893361683671.1223
Cx7_im_a3 x7_im_a3 0 1.0
Gp7_im_re_a3 0 x7_im_a3 x7_re_a3 0 -1893361683671.1223
Rp7_im_im_a3 0 x7_im_a3 1.764884203986438e-11
Cx8_a3 x8_a3 0 1.0
Gx8_a3 0 x8_a3 p3 0 0.07071067811865475
Fx8_a3 0 x8_a3 V3 3.5355339059327378
Rp8_a3 0 x8_a3 7.134017483278191e-13
Cx9_re_a3 x9_re_a3 0 1.0
Gx9_re_a3 0 x9_re_a3 p3 0 0.1414213562373095
Fx9_re_a3 0 x9_re_a3 V3 7.0710678118654755
Rp9_re_re_a3 0 x9_re_a3 1.1810108382102504e-12
Gp9_re_im_a3 0 x9_re_a3 x9_im_a3 0 667262162732.5848
Cx9_im_a3 x9_im_a3 0 1.0
Gp9_im_re_a3 0 x9_im_a3 x9_re_a3 0 -667262162732.5848
Rp9_im_im_a3 0 x9_im_a3 1.1810108382102504e-12
Cx10_a3 x10_a3 0 1.0
Gx10_a3 0 x10_a3 p3 0 0.07071067811865475
Fx10_a3 0 x10_a3 V3 3.5355339059327378
Rp10_a3 0 x10_a3 9.059895014373575e-13
Cx11_a3 x11_a3 0 1.0
Gx11_a3 0 x11_a3 p3 0 0.07071067811865475
Fx11_a3 0 x11_a3 V3 3.5355339059327378
Rp11_a3 0 x11_a3 1.7461165062812219e-12
Cx12_a3 x12_a3 0 1.0
Gx12_a3 0 x12_a3 p3 0 0.07071067811865475
Fx12_a3 0 x12_a3 V3 3.5355339059327378
Rp12_a3 0 x12_a3 2.9716792303835088e-12
Cx13_re_a3 x13_re_a3 0 1.0
Gx13_re_a3 0 x13_re_a3 p3 0 0.1414213562373095
Fx13_re_a3 0 x13_re_a3 V3 7.0710678118654755
Rp13_re_re_a3 0 x13_re_a3 8.809235095423119e-12
Gp13_re_im_a3 0 x13_re_a3 x13_im_a3 0 123160380596.87326
Cx13_im_a3 x13_im_a3 0 1.0
Gp13_im_re_a3 0 x13_im_a3 x13_re_a3 0 -123160380596.87326
Rp13_im_im_a3 0 x13_im_a3 8.809235095423119e-12
Cx14_a3 x14_a3 0 1.0
Gx14_a3 0 x14_a3 p3 0 0.07071067811865475
Fx14_a3 0 x14_a3 V3 3.5355339059327378
Rp14_a3 0 x14_a3 7.766332233640755e-12
Cx15_a3 x15_a3 0 1.0
Gx15_a3 0 x15_a3 p3 0 0.07071067811865475
Fx15_a3 0 x15_a3 V3 3.5355339059327378
Rp15_a3 0 x15_a3 1.8095221673439617e-11
Cx16_re_a3 x16_re_a3 0 1.0
Gx16_re_a3 0 x16_re_a3 p3 0 0.1414213562373095
Fx16_re_a3 0 x16_re_a3 V3 7.0710678118654755
Rp16_re_re_a3 0 x16_re_a3 1.1460445945124401e-10
Gp16_re_im_a3 0 x16_re_a3 x16_im_a3 0 3105731083.7159095
Cx16_im_a3 x16_im_a3 0 1.0
Gp16_im_re_a3 0 x16_im_a3 x16_re_a3 0 -3105731083.7159095
Rp16_im_im_a3 0 x16_im_a3 1.1460445945124401e-10
*
* Port network for port 4
V4 p4 s4 0
R4 s4 0 50.0
Gd4_1 0 s4 p1 0 6.019373819710071e-07
Fd4_1 0 s4 V1 3.0096869098550357e-05
Gr1_4_1 0 s4 x1_a1 0 587799469145.897
Gr2_re_4_1 0 s4 x2_re_a1 0 13632522711.082663
Gr2_im_4_1 0 s4 x2_im_a1 0 -61278073816.44226
Gr3_re_4_1 0 s4 x3_re_a1 0 -16777692479.055634
Gr3_im_4_1 0 s4 x3_im_a1 0 -12087866544.222412
Gr4_re_4_1 0 s4 x4_re_a1 0 -139035322998.22012
Gr4_im_4_1 0 s4 x4_im_a1 0 5198815105.419125
Gr5_re_4_1 0 s4 x5_re_a1 0 -154022627279.98828
Gr5_im_4_1 0 s4 x5_im_a1 0 448919343249.1883
Gr6_re_4_1 0 s4 x6_re_a1 0 -27217974078.26222
Gr6_im_4_1 0 s4 x6_im_a1 0 -1909942550.2427993
Gr7_re_4_1 0 s4 x7_re_a1 0 -20897748.342623435
Gr7_im_4_1 0 s4 x7_im_a1 0 -21209347.33287434
Gr8_4_1 0 s4 x8_a1 0 1973847061267.6707
Gr9_re_4_1 0 s4 x9_re_a1 0 -92403405686.81747
Gr9_im_4_1 0 s4 x9_im_a1 0 -80238603816.79134
Gr10_4_1 0 s4 x10_a1 0 -1219668940919.567
Gr11_4_1 0 s4 x11_a1 0 32671277528.041126
Gr12_4_1 0 s4 x12_a1 0 2815533760.37368
Gr13_re_4_1 0 s4 x13_re_a1 0 -190163736.05014887
Gr13_im_4_1 0 s4 x13_im_a1 0 43687940.21772607
Gr14_4_1 0 s4 x14_a1 0 143072676.11724666
Gr15_4_1 0 s4 x15_a1 0 -177472516.65460125
Gr16_re_4_1 0 s4 x16_re_a1 0 14247165.316253513
Gr16_im_4_1 0 s4 x16_im_a1 0 69106486.06316939
Gd4_2 0 s4 p2 0 8.910094778113996e-07
Fd4_2 0 s4 V2 4.4550473890569986e-05
Gr1_4_2 0 s4 x1_a2 0 -302432050347.08997
Gr2_re_4_2 0 s4 x2_re_a2 0 87232978808.05159
Gr2_im_4_2 0 s4 x2_im_a2 0 65791701576.479034
Gr3_re_4_2 0 s4 x3_re_a2 0 3299504747.9683475
Gr3_im_4_2 0 s4 x3_im_a2 0 -8418351792.740567
Gr4_re_4_2 0 s4 x4_re_a2 0 -37303029154.26777
Gr4_im_4_2 0 s4 x4_im_a2 0 12841992830.266418
Gr5_re_4_2 0 s4 x5_re_a2 0 -239234195718.9719
Gr5_im_4_2 0 s4 x5_im_a2 0 164256167468.8259
Gr6_re_4_2 0 s4 x6_re_a2 0 -14175660317.784084
Gr6_im_4_2 0 s4 x6_im_a2 0 20183360263.743393
Gr7_re_4_2 0 s4 x7_re_a2 0 -3778637.032662467
Gr7_im_4_2 0 s4 x7_im_a2 0 -10398869.04253234
Gr8_4_2 0 s4 x8_a2 0 2020074692854.403
Gr9_re_4_2 0 s4 x9_re_a2 0 26909812098.72639
Gr9_im_4_2 0 s4 x9_im_a2 0 -86417834586.60852
Gr10_4_2 0 s4 x10_a2 0 -1591090155913.0442
Gr11_4_2 0 s4 x11_a2 0 182520682136.38275
Gr12_4_2 0 s4 x12_a2 0 -22470839043.61176
Gr13_re_4_2 0 s4 x13_re_a2 0 313056921.9790193
Gr13_im_4_2 0 s4 x13_im_a2 0 218619409.473012
Gr14_4_2 0 s4 x14_a2 0 2676639530.810628
Gr15_4_2 0 s4 x15_a2 0 -261408479.9457991
Gr16_re_4_2 0 s4 x16_re_a2 0 12294972.0956925
Gr16_im_4_2 0 s4 x16_im_a2 0 50825498.14061637
Gd4_3 0 s4 p3 0 9.034609455116361e-07
Fd4_3 0 s4 V3 4.51730472755818e-05
Gr1_4_3 0 s4 x1_a3 0 987985177298.0382
Gr2_re_4_3 0 s4 x2_re_a3 0 82928783277.42093
Gr2_im_4_3 0 s4 x2_im_a3 0 -127599433148.23596
Gr3_re_4_3 0 s4 x3_re_a3 0 -41282329683.58346
Gr3_im_4_3 0 s4 x3_im_a3 0 -70019551142.4342
Gr4_re_4_3 0 s4 x4_re_a3 0 -100043534931.79245
Gr4_im_4_3 0 s4 x4_im_a3 0 -295668837143.4295
Gr5_re_4_3 0 s4 x5_re_a3 0 -396539600438.1897
Gr5_im_4_3 0 s4 x5_im_a3 0 1457074521560.2568
Gr6_re_4_3 0 s4 x6_re_a3 0 -31113104490.102947
Gr6_im_4_3 0 s4 x6_im_a3 0 9181142787.684961
Gr7_re_4_3 0 s4 x7_re_a3 0 2879925053.6295395
Gr7_im_4_3 0 s4 x7_im_a3 0 -987310567.2909931
Gr8_4_3 0 s4 x8_a3 0 1380478835563.176
Gr9_re_4_3 0 s4 x9_re_a3 0 19152550869.704304
Gr9_im_4_3 0 s4 x9_im_a3 0 -56822700113.08303
Gr10_4_3 0 s4 x10_a3 0 -928151273299.967
Gr11_4_3 0 s4 x11_a3 0 223233626465.37372
Gr12_4_3 0 s4 x12_a3 0 -23390443687.151638
Gr13_re_4_3 0 s4 x13_re_a3 0 396736158.97385895
Gr13_im_4_3 0 s4 x13_im_a3 0 175469773.01096645
Gr14_4_3 0 s4 x14_a3 0 2674598612.693189
Gr15_4_3 0 s4 x15_a3 0 -152152157.0957236
Gr16_re_4_3 0 s4 x16_re_a3 0 10542978.606945742
Gr16_im_4_3 0 s4 x16_im_a3 0 23183120.02870175
Gd4_4 0 s4 p4 0 2.836213719070724e-07
Fd4_4 0 s4 V4 1.418106859535362e-05
Gr1_4_4 0 s4 x1_a4 0 -5864847278998.441
Gr2_re_4_4 0 s4 x2_re_a4 0 4855305111.405386
Gr2_im_4_4 0 s4 x2_im_a4 0 281761616240.1554
Gr3_re_4_4 0 s4 x3_re_a4 0 52835416457.97087
Gr3_im_4_4 0 s4 x3_im_a4 0 69433811512.7147
Gr4_re_4_4 0 s4 x4_re_a4 0 124640163042.41232
Gr4_im_4_4 0 s4 x4_im_a4 0 197942895787.13635
Gr5_re_4_4 0 s4 x5_re_a4 0 1479890463742.5154
Gr5_im_4_4 0 s4 x5_im_a4 0 -243662920664.8798
Gr6_re_4_4 0 s4 x6_re_a4 0 -30876499485.87937
Gr6_im_4_4 0 s4 x6_im_a4 0 9278111511.391174
Gr7_re_4_4 0 s4 x7_re_a4 0 -2871794019.75732
Gr7_im_4_4 0 s4 x7_im_a4 0 976474557.7279181
Gr8_4_4 0 s4 x8_a4 0 4211146733339.424
Gr9_re_4_4 0 s4 x9_re_a4 0 -40367124913.9557
Gr9_im_4_4 0 s4 x9_im_a4 0 -107834663078.53767
Gr10_4_4 0 s4 x10_a4 0 -3381089250115.944
Gr11_4_4 0 s4 x11_a4 0 103407288342.78194
Gr12_4_4 0 s4 x12_a4 0 -46636992582.00238
Gr13_re_4_4 0 s4 x13_re_a4 0 516569235.9262759
Gr13_im_4_4 0 s4 x13_im_a4 0 195888507.21205765
Gr14_4_4 0 s4 x14_a4 0 2504811517.6627035
Gr15_4_4 0 s4 x15_a4 0 -363256492.1313133
Gr16_re_4_4 0 s4 x16_re_a4 0 4576771.26503649
Gr16_im_4_4 0 s4 x16_im_a4 0 23104965.051929545
Gd4_5 0 s4 p5 0 -6.525712629009904e-08
Fd4_5 0 s4 V5 -3.2628563145049518e-06
Gr1_4_5 0 s4 x1_a5 0 2619810021781.891
Gr2_re_4_5 0 s4 x2_re_a5 0 -77035587771.71112
Gr2_im_4_5 0 s4 x2_im_a5 0 -106534976651.6369
Gr3_re_4_5 0 s4 x3_re_a5 0 1750579351.4421916
Gr3_im_4_5 0 s4 x3_im_a5 0 4176430798.8625984
Gr4_re_4_5 0 s4 x4_re_a5 0 -39025817020.90879
Gr4_im_4_5 0 s4 x4_im_a5 0 -42716038885.02032
Gr5_re_4_5 0 s4 x5_re_a5 0 -726672813786.0778
Gr5_im_4_5 0 s4 x5_im_a5 0 -9080417045.45134
Gr6_re_4_5 0 s4 x6_re_a5 0 -18209930383.026184
Gr6_im_4_5 0 s4 x6_im_a5 0 10951630898.564901
Gr7_re_4_5 0 s4 x7_re_a5 0 37111702.92394647
Gr7_im_4_5 0 s4 x7_im_a5 0 -14926752.411100188
Gr8_4_5 0 s4 x8_a5 0 4776963829777.226
Gr9_re_4_5 0 s4 x9_re_a5 0 -60275033616.642944
Gr9_im_4_5 0 s4 x9_im_a5 0 -210607064377.86758
Gr10_4_5 0 s4 x10_a5 0 -4591762858242.031
Gr11_4_5 0 s4 x11_a5 0 473932367733.1403
Gr12_4_5 0 s4 x12_a5 0 -107817219412.8543
Gr13_re_4_5 0 s4 x13_re_a5 0 1564963795.3235736
Gr13_im_4_5 0 s4 x13_im_a5 0 604939932.1759113
Gr14_4_5 0 s4 x14_a5 0 8441831532.101328
Gr15_4_5 0 s4 x15_a5 0 -682180863.5737996
Gr16_re_4_5 0 s4 x16_re_a5 0 13211928.295422034
Gr16_im_4_5 0 s4 x16_im_a5 0 17726779.99740102
Gd4_6 0 s4 p6 0 2.3308428372855945e-07
Fd4_6 0 s4 V6 1.1654214186427973e-05
Gr1_4_6 0 s4 x1_a6 0 1029884753566.6248
Gr2_re_4_6 0 s4 x2_re_a6 0 -16005780069.033606
Gr2_im_4_6 0 s4 x2_im_a6 0 1936039867.2489455
Gr3_re_4_6 0 s4 x3_re_a6 0 12650752429.39758
Gr3_im_4_6 0 s4 x3_im_a6 0 14726295659.944284
Gr4_re_4_6 0 s4 x4_re_a6 0 137477080757.8575
Gr4_im_4_6 0 s4 x4_im_a6 0 40669872626.87351
Gr5_re_4_6 0 s4 x5_re_a6 0 -124591043986.59146
Gr5_im_4_6 0 s4 x5_im_a6 0 -832524411124.8927
Gr6_re_4_6 0 s4 x6_re_a6 0 -22223697852.513992
Gr6_im_4_6 0 s4 x6_im_a6 0 10639621.898078866
Gr7_re_4_6 0 s4 x7_re_a6 0 12009062.804873755
Gr7_im_4_6 0 s4 x7_im_a6 0 21941282.749389812
Gr8_4_6 0 s4 x8_a6 0 -3190467541517.437
Gr9_re_4_6 0 s4 x9_re_a6 0 97449361010.71167
Gr9_im_4_6 0 s4 x9_im_a6 0 124537555480.18065
Gr10_4_6 0 s4 x10_a6 0 2277012583202.193
Gr11_4_6 0 s4 x11_a6 0 -139897900900.14575
Gr12_4_6 0 s4 x12_a6 0 17450987698.08661
Gr13_re_4_6 0 s4 x13_re_a6 0 -110016666.98551753
Gr13_im_4_6 0 s4 x13_im_a6 0 -19564636.685404904
Gr14_4_6 0 s4 x14_a6 0 -1003930546.7297412
Gr15_4_6 0 s4 x15_a6 0 158220275.74461454
Gr16_re_4_6 0 s4 x16_re_a6 0 -6334605.878549556
Gr16_im_4_6 0 s4 x16_im_a6 0 -35485105.20363085
Gd4_7 0 s4 p7 0 1.635894625035515e-07
Fd4_7 0 s4 V7 8.179473125177576e-06
Gr1_4_7 0 s4 x1_a7 0 -95894751465.13576
Gr2_re_4_7 0 s4 x2_re_a7 0 -127885872045.21022
Gr2_im_4_7 0 s4 x2_im_a7 0 -120198784762.5105
Gr3_re_4_7 0 s4 x3_re_a7 0 24737637611.68751
Gr3_im_4_7 0 s4 x3_im_a7 0 -99752800887.27423
Gr4_re_4_7 0 s4 x4_re_a7 0 35933731555.22519
Gr4_im_4_7 0 s4 x4_im_a7 0 361075547285.32117
Gr5_re_4_7 0 s4 x5_re_a7 0 -115075666217.05302
Gr5_im_4_7 0 s4 x5_im_a7 0 94973168303.42238
Gr6_re_4_7 0 s4 x6_re_a7 0 -31166727929.364918
Gr6_im_4_7 0 s4 x6_im_a7 0 3081038054.177593
Gr7_re_4_7 0 s4 x7_re_a7 0 3053737012.2216296
Gr7_im_4_7 0 s4 x7_im_a7 0 -212418240.32317343
Gr8_4_7 0 s4 x8_a7 0 473857079669.52246
Gr9_re_4_7 0 s4 x9_re_a7 0 -22422047119.160904
Gr9_im_4_7 0 s4 x9_im_a7 0 59088028233.118675
Gr10_4_7 0 s4 x10_a7 0 299106725468.59717
Gr11_4_7 0 s4 x11_a7 0 -198019544429.2069
Gr12_4_7 0 s4 x12_a7 0 21797359780.831657
Gr13_re_4_7 0 s4 x13_re_a7 0 -345200762.76836693
Gr13_im_4_7 0 s4 x13_im_a7 0 -119506664.17267156
Gr14_4_7 0 s4 x14_a7 0 -1955855518.9450808
Gr15_4_7 0 s4 x15_a7 0 132288623.5071627
Gr16_re_4_7 0 s4 x16_re_a7 0 -5891319.908012644
Gr16_im_4_7 0 s4 x16_im_a7 0 -11847678.790990166
Gd4_8 0 s4 p8 0 3.3282800140689747e-07
Fd4_8 0 s4 V8 1.6641400070344873e-05
Gr1_4_8 0 s4 x1_a8 0 552126289144.1165
Gr2_re_4_8 0 s4 x2_re_a8 0 -57505423374.01142
Gr2_im_4_8 0 s4 x2_im_a8 0 -89357470685.61557
Gr3_re_4_8 0 s4 x3_re_a8 0 -26044412246.454807
Gr3_im_4_8 0 s4 x3_im_a8 0 107429605754.99437
Gr4_re_4_8 0 s4 x4_re_a8 0 -16791289916.351484
Gr4_im_4_8 0 s4 x4_im_a8 0 -294446207470.0425
Gr5_re_4_8 0 s4 x5_re_a8 0 465280734408.033
Gr5_im_4_8 0 s4 x5_im_a8 0 48546105491.240746
Gr6_re_4_8 0 s4 x6_re_a8 0 -31160871684.605503
Gr6_im_4_8 0 s4 x6_im_a8 0 3121631637.857806
Gr7_re_4_8 0 s4 x7_re_a8 0 -3061166991.1724186
Gr7_im_4_8 0 s4 x7_im_a8 0 225109512.3197464
Gr8_4_8 0 s4 x8_a8 0 -3297334524464.299
Gr9_re_4_8 0 s4 x9_re_a8 0 8814668088.619938
Gr9_im_4_8 0 s4 x9_im_a8 0 56168028784.66537
Gr10_4_8 0 s4 x10_a8 0 2147074844999.679
Gr11_4_8 0 s4 x11_a8 0 -5079101413.637947
Gr12_4_8 0 s4 x12_a8 0 26201975903.173275
Gr13_re_4_8 0 s4 x13_re_a8 0 -328620375.9951702
Gr13_im_4_8 0 s4 x13_im_a8 0 -119188332.65026997
Gr14_4_8 0 s4 x14_a8 0 -1625795753.7326052
Gr15_4_8 0 s4 x15_a8 0 161044697.0267549
Gr16_re_4_8 0 s4 x16_re_a8 0 -109350.0813328784
Gr16_im_4_8 0 s4 x16_im_a8 0 -11197407.39209628
*
* State networks driven by port 4
Cx1_a4 x1_a4 0 1.0
Gx1_a4 0 x1_a4 p4 0 0.07071067811865475
Fx1_a4 0 x1_a4 V4 3.5355339059327378
Rp1_a4 0 x1_a4 1.2667707539388034e-13
Cx2_re_a4 x2_re_a4 0 1.0
Gx2_re_a4 0 x2_re_a4 p4 0 0.1414213562373095
Fx2_re_a4 0 x2_re_a4 V4 7.0710678118654755
Rp2_re_re_a4 0 x2_re_a4 9.289804648696368e-13
Gp2_re_im_a4 0 x2_re_a4 x2_im_a4 0 3958398257259.3657
Cx2_im_a4 x2_im_a4 0 1.0
Gp2_im_re_a4 0 x2_im_a4 x2_re_a4 0 -3958398257259.3657
Rp2_im_im_a4 0 x2_im_a4 9.289804648696368e-13
Cx3_re_a4 x3_re_a4 0 1.0
Gx3_re_a4 0 x3_re_a4 p4 0 0.1414213562373095
Fx3_re_a4 0 x3_re_a4 V4 7.0710678118654755
Rp3_re_re_a4 0 x3_re_a4 1.8873881915204676e-12
Gp3_re_im_a4 0 x3_re_a4 x3_im_a4 0 3441166588437.5947
Cx3_im_a4 x3_im_a4 0 1.0
Gp3_im_re_a4 0 x3_im_a4 x3_re_a4 0 -3441166588437.5947
Rp3_im_im_a4 0 x3_im_a4 1.8873881915204676e-12
Cx4_re_a4 x4_re_a4 0 1.0
Gx4_re_a4 0 x4_re_a4 p4 0 0.1414213562373095
Fx4_re_a4 0 x4_re_a4 V4 7.0710678118654755
Rp4_re_re_a4 0 x4_re_a4 9.922592044099783e-13
Gp4_re_im_a4 0 x4_re_a4 x4_im_a4 0 3220889250610.056
Cx4_im_a4 x4_im_a4 0 1.0
Gp4_im_re_a4 0 x4_im_a4 x4_re_a4 0 -3220889250610.056
Rp4_im_im_a4 0 x4_im_a4 9.922592044099783e-13
Cx5_re_a4 x5_re_a4 0 1.0
Gx5_re_a4 0 x5_re_a4 p4 0 0.1414213562373095
Fx5_re_a4 0 x5_re_a4 V4 7.0710678118654755
Rp5_re_re_a4 0 x5_re_a4 4.2837375484112484e-13
Gp5_re_im_a4 0 x5_re_a4 x5_im_a4 0 2073506969966.306
Cx5_im_a4 x5_im_a4 0 1.0
Gp5_im_re_a4 0 x5_im_a4 x5_re_a4 0 -2073506969966.306
Rp5_im_im_a4 0 x5_im_a4 4.2837375484112484e-13
Cx6_re_a4 x6_re_a4 0 1.0
Gx6_re_a4 0 x6_re_a4 p4 0 0.1414213562373095
Fx6_re_a4 0 x6_re_a4 V4 7.0710678118654755
Rp6_re_re_a4 0 x6_re_a4 2.8457065637511862e-12
Gp6_re_im_a4 0 x6_re_a4 x6_im_a4 0 2302996887167.347
Cx6_im_a4 x6_im_a4 0 1.0
Gp6_im_re_a4 0 x6_im_a4 x6_re_a4 0 -2302996887167.347
Rp6_im_im_a4 0 x6_im_a4 2.8457065637511862e-12
Cx7_re_a4 x7_re_a4 0 1.0
Gx7_re_a4 0 x7_re_a4 p4 0 0.1414213562373095
Fx7_re_a4 0 x7_re_a4 V4 7.0710678118654755
Rp7_re_re_a4 0 x7_re_a4 1.764884203986438e-11
Gp7_re_im_a4 0 x7_re_a4 x7_im_a4 0 1893361683671.1223
Cx7_im_a4 x7_im_a4 0 1.0
Gp7_im_re_a4 0 x7_im_a4 x7_re_a4 0 -1893361683671.1223
Rp7_im_im_a4 0 x7_im_a4 1.764884203986438e-11
Cx8_a4 x8_a4 0 1.0
Gx8_a4 0 x8_a4 p4 0 0.07071067811865475
Fx8_a4 0 x8_a4 V4 3.5355339059327378
Rp8_a4 0 x8_a4 7.134017483278191e-13
Cx9_re_a4 x9_re_a4 0 1.0
Gx9_re_a4 0 x9_re_a4 p4 0 0.1414213562373095
Fx9_re_a4 0 x9_re_a4 V4 7.0710678118654755
Rp9_re_re_a4 0 x9_re_a4 1.1810108382102504e-12
Gp9_re_im_a4 0 x9_re_a4 x9_im_a4 0 667262162732.5848
Cx9_im_a4 x9_im_a4 0 1.0
Gp9_im_re_a4 0 x9_im_a4 x9_re_a4 0 -667262162732.5848
Rp9_im_im_a4 0 x9_im_a4 1.1810108382102504e-12
Cx10_a4 x10_a4 0 1.0
Gx10_a4 0 x10_a4 p4 0 0.07071067811865475
Fx10_a4 0 x10_a4 V4 3.5355339059327378
Rp10_a4 0 x10_a4 9.059895014373575e-13
Cx11_a4 x11_a4 0 1.0
Gx11_a4 0 x11_a4 p4 0 0.07071067811865475
Fx11_a4 0 x11_a4 V4 3.5355339059327378
Rp11_a4 0 x11_a4 1.7461165062812219e-12
Cx12_a4 x12_a4 0 1.0
Gx12_a4 0 x12_a4 p4 0 0.07071067811865475
Fx12_a4 0 x12_a4 V4 3.5355339059327378
Rp12_a4 0 x12_a4 2.9716792303835088e-12
Cx13_re_a4 x13_re_a4 0 1.0
Gx13_re_a4 0 x13_re_a4 p4 0 0.1414213562373095
Fx13_re_a4 0 x13_re_a4 V4 7.0710678118654755
Rp13_re_re_a4 0 x13_re_a4 8.809235095423119e-12
Gp13_re_im_a4 0 x13_re_a4 x13_im_a4 0 123160380596.87326
Cx13_im_a4 x13_im_a4 0 1.0
Gp13_im_re_a4 0 x13_im_a4 x13_re_a4 0 -123160380596.87326
Rp13_im_im_a4 0 x13_im_a4 8.809235095423119e-12
Cx14_a4 x14_a4 0 1.0
Gx14_a4 0 x14_a4 p4 0 0.07071067811865475
Fx14_a4 0 x14_a4 V4 3.5355339059327378
Rp14_a4 0 x14_a4 7.766332233640755e-12
Cx15_a4 x15_a4 0 1.0
Gx15_a4 0 x15_a4 p4 0 0.07071067811865475
Fx15_a4 0 x15_a4 V4 3.5355339059327378
Rp15_a4 0 x15_a4 1.8095221673439617e-11
Cx16_re_a4 x16_re_a4 0 1.0
Gx16_re_a4 0 x16_re_a4 p4 0 0.1414213562373095
Fx16_re_a4 0 x16_re_a4 V4 7.0710678118654755
Rp16_re_re_a4 0 x16_re_a4 1.1460445945124401e-10
Gp16_re_im_a4 0 x16_re_a4 x16_im_a4 0 3105731083.7159095
Cx16_im_a4 x16_im_a4 0 1.0
Gp16_im_re_a4 0 x16_im_a4 x16_re_a4 0 -3105731083.7159095
Rp16_im_im_a4 0 x16_im_a4 1.1460445945124401e-10
*
* Port network for port 5
V5 p5 s5 0
R5 s5 0 50.0
Gd5_1 0 s5 p1 0 5.496084387630189e-07
Fd5_1 0 s5 V1 2.7480421938150947e-05
Gr1_5_1 0 s5 x1_a1 0 746688892638.1825
Gr2_re_5_1 0 s5 x2_re_a1 0 50568991911.27815
Gr2_im_5_1 0 s5 x2_im_a1 0 126140575658.27315
Gr3_re_5_1 0 s5 x3_re_a1 0 12429148417.388191
Gr3_im_5_1 0 s5 x3_im_a1 0 25114293148.02094
Gr4_re_5_1 0 s5 x4_re_a1 0 165647262505.46255
Gr4_im_5_1 0 s5 x4_im_a1 0 -191522605476.7092
Gr5_re_5_1 0 s5 x5_re_a1 0 -645535358679.1448
Gr5_im_5_1 0 s5 x5_im_a1 0 -300771511664.78723
Gr6_re_5_1 0 s5 x6_re_a1 0 -14295398994.082977
Gr6_im_5_1 0 s5 x6_im_a1 0 1938110150.401525
Gr7_re_5_1 0 s5 x7_re_a1 0 99089607.11967738
Gr7_im_5_1 0 s5 x7_im_a1 0 5781692.447890528
Gr8_5_1 0 s5 x8_a1 0 5976213804512.323
Gr9_re_5_1 0 s5 x9_re_a1 0 157960598580.76114
Gr9_im_5_1 0 s5 x9_im_a1 0 -233049428589.81207
Gr10_5_1 0 s5 x10_a1 0 -6454064587891.714
Gr11_5_1 0 s5 x11_a1 0 881858931573.5469
Gr12_5_1 0 s5 x12_a1 0 -180791916140.254
Gr13_re_5_1 0 s5 x13_re_a1 0 2710969129.040561
Gr13_im_5_1 0 s5 x13_im_a1 0 791896742.8589197
Gr14_5_1 0 s5 x14_a1 0 13694879356.79676
Gr15_5_1 0 s5 x15_a1 0 -1000053044.326732
Gr16_re_5_1 0 s5 x16_re_a1 0 17815835.462011427
Gr16_im_5_1 0 s5 x16_im_a1 0 21124646.907809734
Gd5_2 0 s5 p2 0 -2.176806984241497e-07
Fd5_2 0 s5 V2 -1.0884034921207486e-05
Gr1_5_2 0 s5 x1_a2 0 38930547041.60253
Gr2_re_5_2 0 s5 x2_re_a2 0 -96405257576.16158
Gr2_im_5_2 0 s5 x2_im_a2 0 -290865458811.4998
Gr3_re_5_2 0 s5 x3_re_a2 0 67789865.3718486
Gr3_im_5_2 0 s5 x3_im_a2 0 -10839489037.081064
Gr4_re_5_2 0 s5 x4_re_a2 0 -170540238368.5182
Gr4_im_5_2 0 s5 x4_im_a2 0 -5620930559.324036
Gr5_re_5_2 0 s5 x5_re_a2 0 -296119184562.3084
Gr5_im_5_2 0 s5 x5_im_a2 0 1124337672544.1438
Gr6_re_5_2 0 s5 x6_re_a2 0 -5973701345.487399
Gr6_im_5_2 0 s5 x6_im_a2 0 15116241376.273228
Gr7_re_5_2 0 s5 x7_re_a2 0 8439191.519879002
Gr7_im_5_2 0 s5 x7_im_a2 0 -27426697.91539246
Gr8_5_2 0 s5 x8_a2 0 6472140233147.598
Gr9_re_5_2 0 s5 x9_re_a2 0 -220888930634.82922
Gr9_im_5_2 0 s5 x9_im_a2 0 -144328912471.21017
Gr10_5_2 0 s5 x10_a2 0 -5350715152759.562
Gr11_5_2 0 s5 x11_a2 0 637799095369.8116
Gr12_5_2 0 s5 x12_a2 0 -91336238818.90648
Gr13_re_5_2 0 s5 x13_re_a2 0 1331866716.2162237
Gr13_im_5_2 0 s5 x13_im_a2 0 671988794.6050948
Gr14_5_2 0 s5 x14_a2 0 8846133113.038967
Gr15_5_2 0 s5 x15_a2 0 -735154242.575432
Gr16_re_5_2 0 s5 x16_re_a2 0 22626762.623161156
Gr16_im_5_2 0 s5 x16_im_a2 0 52171059.176002294
Gd5_3 0 s5 p3 0 -7.393551031324372e-08
Fd5_3 0 s5 V3 -3.6967755156621864e-06
Gr1_5_3 0 s5 x1_a3 0 2592963047181.0527
Gr2_re_5_3 0 s5 x2_re_a3 0 -78207296514.99736
Gr2_im_5_3 0 s5 x2_im_a3 0 -104285949431.16245
Gr3_re_5_3 0 s5 x3_re_a3 0 2148919321.398073
Gr3_im_5_3 0 s5 x3_im_a3 0 5016138989.3809185
Gr4_re_5_3 0 s5 x4_re_a3 0 -36328567170.18933
Gr4_im_5_3 0 s5 x4_im_a3 0 -46191938014.133575
Gr5_re_5_3 0 s5 x5_re_a3 0 -745985163710.4126
Gr5_im_5_3 0 s5 x5_im_a3 0 10998918928.481392
Gr6_re_5_3 0 s5 x6_re_a3 0 -18130891407.4273
Gr6_im_5_3 0 s5 x6_im_a3 0 10873759134.899199
Gr7_re_5_3 0 s5 x7_re_a3 0 39329673.479131304
Gr7_im_5_3 0 s5 x7_im_a3 0 -13772704.611212205
Gr8_5_3 0 s5 x8_a3 0 5152329635144.833
Gr9_re_5_3 0 s5 x9_re_a3 0 -61189758715.93061
Gr9_im_5_3 0 s5 x9_im_a3 0 -227272401035.26834
Gr10_5_3 0 s5 x10_a3 0 -4937662294949.054
Gr11_5_3 0 s5 x11_a3 0 511800948403.6447
Gr12_5_3 0 s5 x12_a3 0 -115358679915.67964
Gr13_re_5_3 0 s5 x13_re_a3 0 1674926626.6232798
Gr13_im_5_3 0 s5 x13_im_a3 0 643008655.2823586
Gr14_5_3 0 s5 x14_a3 0 9030523505.39328
Gr15_5_3 0 s5 x15_a3 0 -726319235.8373225
Gr16_re_5_3 0 s5 x16_re_a3 0 14012555.075420769
Gr16_im_5_3 0 s5 x16_im_a3 0 18752186.82693014
Gd5_4 0 s5 p4 0 -6.525712629009904e-08
Fd5_4 0 s5 V4 -3.2628563145049518e-06
Gr1_5_4 0 s5 x1_a4 0 2619810021781.865
Gr2_re_5_4 0 s5 x2_re_a4 0 -77035587771.71173
Gr2_im_5_4 0 s5 x2_im_a4 0 -106534976651.6363
Gr3_re_5_4 0 s5 x3_re_a4 0 1750579351.442642
Gr3_im_5_4 0 s5 x3_im_a4 0 4176430798.8627415
Gr4_re_5_4 0 s5 x4_re_a4 0 -39025817020.909386
Gr4_im_5_4 0 s5 x4_im_a4 0 -42716038885.02148
Gr5_re_5_4 0 s5 x5_re_a4 0 -726672813786.0784
Gr5_im_5_4 0 s5 x5_im_a4 0 -9080417045.435833
Gr6_re_5_4 0 s5 x6_re_a4 0 -18209930383.02619
Gr6_im_5_4 0 s5 x6_im_a4 0 10951630898.564903
Gr7_re_5_4 0 s5 x7_re_a4 0 37111702.92394378
Gr7_im_5_4 0 s5 x7_im_a4 0 -14926752.411067972
Gr8_5_4 0 s5 x8_a4 0 4776963829777.273
Gr9_re_5_4 0 s5 x9_re_a4 0 -60275033616.64935
Gr9_im_5_4 0 s5 x9_im_a4 0 -210607064377.8689
Gr10_5_4 0 s5 x10_a4 0 -4591762858242.036
Gr11_5_4 0 s5 x11_a4 0 473932367733.12006
Gr12_5_4 0 s5 x12_a4 0 -107817219412.84505
Gr13_re_5_4 0 s5 x13_re_a4 0 1564963795.3233843
Gr13_im_5_4 0 s5 x13_im_a4 0 604939932.1756332
Gr14_5_4 0 s5 x14_a4 0 8441831532.099342
Gr15_5_4 0 s5 x15_a4 0 -682180863.5734465
Gr16_re_5_4 0 s5 x16_re_a4 0 13211928.295389349
Gr16_im_5_4 0 s5 x16_im_a4 0 17726779.997352503
Gd5_5 0 s5 p5 0 3.786753361256778e-07
Fd5_5 0 s5 V5 1.893376680628389e-05
Gr1_5_5 0 s5 x1_a5 0 -3151837676013.4863
Gr2_re_5_5 0 s5 x2_re_a5 0 -184497277938.69583
Gr2_im_5_5 0 s5 x2_im_a5 0 344004484302.059
Gr3_re_5_5 0 s5 x3_re_a5 0 -9464547999.389023
Gr3_im_5_5 0 s5 x3_im_a5 0 -10887235021.91108
Gr4_re_5_5 0 s5 x4_re_a5 0 124830601162.92987
Gr4_im_5_5 0 s5 x4_im_a5 0 270062167290.78015
Gr5_re_5_5 0 s5 x5_re_a5 0 2082410122473.359
Gr5_im_5_5 0 s5 x5_im_a5 0 29164652825.556835
Gr6_re_5_5 0 s5 x6_re_a5 0 -12807577706.043602
Gr6_im_5_5 0 s5 x6_im_a5 0 16119632776.980698
Gr7_re_5_5 0 s5 x7_re_a5 0 -131375920.71886241
Gr7_im_5_5 0 s5 x7_im_a5 0 43045247.33956822
Gr8_5_5 0 s5 x8_a5 0 -13743305714144.732
Gr9_re_5_5 0 s5 x9_re_a5 0 134325370137.33334
Gr9_im_5_5 0 s5 x9_im_a5 0 636625901836.9384
Gr10_5_5 0 s5 x10_a5 0 13470218965901.023
Gr11_5_5 0 s5 x11_a5 0 -1715020346134.5593
Gr12_5_5 0 s5 x12_a5 0 311662662255.0723
Gr13_re_5_5 0 s5 x13_re_a5 0 -4628652795.924575
Gr13_im_5_5 0 s5 x13_im_a5 0 -1459057110.4910214
Gr14_5_5 0 s5 x14_a5 0 -24854294898.026604
Gr15_5_5 0 s5 x15_a5 0 1717125262.6494603
Gr16_re_5_5 0 s5 x16_re_a5 0 -32364781.66034789
Gr16_im_5_5 0 s5 x16_im_a5 0 -39400750.97102295
Gd5_6 0 s5 p6 0 -1.1977814910912877e-07
Fd5_6 0 s5 V6 -5.988907455456438e-06
Gr1_5_6 0 s5 x1_a6 0 -880964889258.8451
Gr2_re_5_6 0 s5 x2_re_a6 0 -148772481752.00674
Gr2_im_5_6 0 s5 x2_im_a6 0 -198676771255.7413
Gr3_re_5_6 0 s5 x3_re_a6 0 -42847055566.41532
Gr3_im_5_6 0 s5 x3_im_a6 0 -24783668111.976383
Gr4_re_5_6 0 s5 x4_re_a6 0 -74418489616.7454
Gr4_im_5_6 0 s5 x4_im_a6 0 433836611970.2158
Gr5_re_5_6 0 s5 x5_re_a6 0 2493135314439.063
Gr5_im_5_6 0 s5 x5_im_a6 0 -663347469044.815
Gr6_re_5_6 0 s5 x6_re_a6 0 -20662486745.87312
Gr6_im_5_6 0 s5 x6_im_a6 0 10672014283.085114
Gr7_re_5_6 0 s5 x7_re_a6 0 -225483124.43223688
Gr7_im_5_6 0 s5 x7_im_a6 0 52358065.427569024
Gr8_5_6 0 s5 x8_a6 0 -25323637400660.746
Gr9_re_5_6 0 s5 x9_re_a6 0 -91618337197.6504
Gr9_im_5_6 0 s5 x9_im_a6 0 1099108472947.9802
Gr10_5_6 0 s5 x10_a6 0 24246805629526.312
Gr11_5_6 0 s5 x11_a6 0 -2793095735374.494
Gr12_5_6 0 s5 x12_a6 0 555565109128.4216
Gr13_re_5_6 0 s5 x13_re_a6 0 -8119412207.709614
Gr13_im_5_6 0 s5 x13_im_a6 0 -2487425551.3900266
Gr14_5_6 0 s5 x14_a6 0 -42085265478.45273
Gr15_5_6 0 s5 x15_a6 0 3036452490.610946
Gr16_re_5_6 0 s5 x16_re_a6 0 -51872976.38779652
Gr16_im_5_6 0 s5 x16_im_a6 0 -47679224.99719329
Gd5_7 0 s5 p7 0 2.530158868285781e-07
Fd5_7 0 s5 V7 1.2650794341428906e-05
Gr1_5_7 0 s5 x1_a7 0 -433272129271.00244
Gr2_re_5_7 0 s5 x2_re_a7 0 24000029664.157917
Gr2_im_5_7 0 s5 x2_im_a7 0 97694416634.58635
Gr3_re_5_7 0 s5 x3_re_a7 0 14646915545.784973
Gr3_im_5_7 0 s5 x3_im_a7 0 4838996177.321774
Gr4_re_5_7 0 s5 x4_re_a7 0 -8204828488.158065
Gr4_im_5_7 0 s5 x4_im_a7 0 -60933565030.150116
Gr5_re_5_7 0 s5 x5_re_a7 0 -577032069110.3663
Gr5_im_5_7 0 s5 x5_im_a7 0 473044474052.0024
Gr6_re_5_7 0 s5 x6_re_a7 0 -19588236223.57637
Gr6_im_5_7 0 s5 x6_im_a7 0 6138963482.80949
Gr7_re_5_7 0 s5 x7_re_a7 0 48739794.77697115
Gr7_im_5_7 0 s5 x7_im_a7 0 -22276036.459736355
Gr8_5_7 0 s5 x8_a7 0 8289965204286.289
Gr9_re_5_7 0 s5 x9_re_a7 0 11609161983.07358
Gr9_im_5_7 0 s5 x9_im_a7 0 -366771515565.96655
Gr10_5_7 0 s5 x10_a7 0 -7467813282315.825
Gr11_5_7 0 s5 x11_a7 0 838215950216.0846
Gr12_5_7 0 s5 x12_a7 0 -151383908423.88614
Gr13_re_5_7 0 s5 x13_re_a7 0 2173305042.6982136
Gr13_im_5_7 0 s5 x13_im_a7 0 650222373.817834
Gr14_5_7 0 s5 x14_a7 0 11732784293.707148
Gr15_5_7 0 s5 x15_a7 0 -837479863.1909652
Gr16_re_5_7 0 s5 x16_re_a7 0 17022110.803151965
Gr16_im_5_7 0 s5 x16_im_a7 0 35813223.29644123
Gd5_8 0 s5 p8 0 2.956152009980783e-07
Fd5_8 0 s5 V8 1.4780760049903917e-05
Gr1_5_8 0 s5 x1_a8 0 -448651488416.9922
Gr2_re_5_8 0 s5 x2_re_a8 0 24377287614.048885
Gr2_im_5_8 0 s5 x2_im_a8 0 97135287448.70293
Gr3_re_5_8 0 s5 x3_re_a8 0 14890756105.311874
Gr3_im_5_8 0 s5 x3_im_a8 0 4756396749.68597
Gr4_re_5_8 0 s5 x4_re_a8 0 -9764572108.31185
Gr4_im_5_8 0 s5 x4_im_a8 0 -62220242289.10573
Gr5_re_5_8 0 s5 x5_re_a8 0 -583234882335.6737
Gr5_im_5_8 0 s5 x5_im_a8 0 489683690695.9215
Gr6_re_5_8 0 s5 x6_re_a8 0 -19600019653.650196
Gr6_im_5_8 0 s5 x6_im_a8 0 6102558042.374947
Gr7_re_5_8 0 s5 x7_re_a8 0 50279842.0246795
Gr7_im_5_8 0 s5 x7_im_a8 0 -24072088.276478626
Gr8_5_8 0 s5 x8_a8 0 8429378203494.951
Gr9_re_5_8 0 s5 x9_re_a8 0 10031589084.639858
Gr9_im_5_8 0 s5 x9_im_a8 0 -371829825859.1565
Gr10_5_8 0 s5 x10_a8 0 -7584045613736.097
Gr11_5_8 0 s5 x11_a8 0 848453679697.3573
Gr12_5_8 0 s5 x12_a8 0 -153190438356.8528
Gr13_re_5_8 0 s5 x13_re_a8 0 2197338359.0255084
Gr13_im_5_8 0 s5 x13_im_a8 0 656657626.3411108
Gr14_5_8 0 s5 x14_a8 0 11857926183.26871
Gr15_5_8 0 s5 x15_a8 0 -846185369.6179771
Gr16_re_5_8 0 s5 x16_re_a8 0 17162350.56197843
Gr16_im_5_8 0 s5 x16_im_a8 0 35973707.32605526
*
* State networks driven by port 5
Cx1_a5 x1_a5 0 1.0
Gx1_a5 0 x1_a5 p5 0 0.07071067811865475
Fx1_a5 0 x1_a5 V5 3.5355339059327378
Rp1_a5 0 x1_a5 1.2667707539388034e-13
Cx2_re_a5 x2_re_a5 0 1.0
Gx2_re_a5 0 x2_re_a5 p5 0 0.1414213562373095
Fx2_re_a5 0 x2_re_a5 V5 7.0710678118654755
Rp2_re_re_a5 0 x2_re_a5 9.289804648696368e-13
Gp2_re_im_a5 0 x2_re_a5 x2_im_a5 0 3958398257259.3657
Cx2_im_a5 x2_im_a5 0 1.0
Gp2_im_re_a5 0 x2_im_a5 x2_re_a5 0 -3958398257259.3657
Rp2_im_im_a5 0 x2_im_a5 9.289804648696368e-13
Cx3_re_a5 x3_re_a5 0 1.0
Gx3_re_a5 0 x3_re_a5 p5 0 0.1414213562373095
Fx3_re_a5 0 x3_re_a5 V5 7.0710678118654755
Rp3_re_re_a5 0 x3_re_a5 1.8873881915204676e-12
Gp3_re_im_a5 0 x3_re_a5 x3_im_a5 0 3441166588437.5947
Cx3_im_a5 x3_im_a5 0 1.0
Gp3_im_re_a5 0 x3_im_a5 x3_re_a5 0 -3441166588437.5947
Rp3_im_im_a5 0 x3_im_a5 1.8873881915204676e-12
Cx4_re_a5 x4_re_a5 0 1.0
Gx4_re_a5 0 x4_re_a5 p5 0 0.1414213562373095
Fx4_re_a5 0 x4_re_a5 V5 7.0710678118654755
Rp4_re_re_a5 0 x4_re_a5 9.922592044099783e-13
Gp4_re_im_a5 0 x4_re_a5 x4_im_a5 0 3220889250610.056
Cx4_im_a5 x4_im_a5 0 1.0
Gp4_im_re_a5 0 x4_im_a5 x4_re_a5 0 -3220889250610.056
Rp4_im_im_a5 0 x4_im_a5 9.922592044099783e-13
Cx5_re_a5 x5_re_a5 0 1.0
Gx5_re_a5 0 x5_re_a5 p5 0 0.1414213562373095
Fx5_re_a5 0 x5_re_a5 V5 7.0710678118654755
Rp5_re_re_a5 0 x5_re_a5 4.2837375484112484e-13
Gp5_re_im_a5 0 x5_re_a5 x5_im_a5 0 2073506969966.306
Cx5_im_a5 x5_im_a5 0 1.0
Gp5_im_re_a5 0 x5_im_a5 x5_re_a5 0 -2073506969966.306
Rp5_im_im_a5 0 x5_im_a5 4.2837375484112484e-13
Cx6_re_a5 x6_re_a5 0 1.0
Gx6_re_a5 0 x6_re_a5 p5 0 0.1414213562373095
Fx6_re_a5 0 x6_re_a5 V5 7.0710678118654755
Rp6_re_re_a5 0 x6_re_a5 2.8457065637511862e-12
Gp6_re_im_a5 0 x6_re_a5 x6_im_a5 0 2302996887167.347
Cx6_im_a5 x6_im_a5 0 1.0
Gp6_im_re_a5 0 x6_im_a5 x6_re_a5 0 -2302996887167.347
Rp6_im_im_a5 0 x6_im_a5 2.8457065637511862e-12
Cx7_re_a5 x7_re_a5 0 1.0
Gx7_re_a5 0 x7_re_a5 p5 0 0.1414213562373095
Fx7_re_a5 0 x7_re_a5 V5 7.0710678118654755
Rp7_re_re_a5 0 x7_re_a5 1.764884203986438e-11
Gp7_re_im_a5 0 x7_re_a5 x7_im_a5 0 1893361683671.1223
Cx7_im_a5 x7_im_a5 0 1.0
Gp7_im_re_a5 0 x7_im_a5 x7_re_a5 0 -1893361683671.1223
Rp7_im_im_a5 0 x7_im_a5 1.764884203986438e-11
Cx8_a5 x8_a5 0 1.0
Gx8_a5 0 x8_a5 p5 0 0.07071067811865475
Fx8_a5 0 x8_a5 V5 3.5355339059327378
Rp8_a5 0 x8_a5 7.134017483278191e-13
Cx9_re_a5 x9_re_a5 0 1.0
Gx9_re_a5 0 x9_re_a5 p5 0 0.1414213562373095
Fx9_re_a5 0 x9_re_a5 V5 7.0710678118654755
Rp9_re_re_a5 0 x9_re_a5 1.1810108382102504e-12
Gp9_re_im_a5 0 x9_re_a5 x9_im_a5 0 667262162732.5848
Cx9_im_a5 x9_im_a5 0 1.0
Gp9_im_re_a5 0 x9_im_a5 x9_re_a5 0 -667262162732.5848
Rp9_im_im_a5 0 x9_im_a5 1.1810108382102504e-12
Cx10_a5 x10_a5 0 1.0
Gx10_a5 0 x10_a5 p5 0 0.07071067811865475
Fx10_a5 0 x10_a5 V5 3.5355339059327378
Rp10_a5 0 x10_a5 9.059895014373575e-13
Cx11_a5 x11_a5 0 1.0
Gx11_a5 0 x11_a5 p5 0 0.07071067811865475
Fx11_a5 0 x11_a5 V5 3.5355339059327378
Rp11_a5 0 x11_a5 1.7461165062812219e-12
Cx12_a5 x12_a5 0 1.0
Gx12_a5 0 x12_a5 p5 0 0.07071067811865475
Fx12_a5 0 x12_a5 V5 3.5355339059327378
Rp12_a5 0 x12_a5 2.9716792303835088e-12
Cx13_re_a5 x13_re_a5 0 1.0
Gx13_re_a5 0 x13_re_a5 p5 0 0.1414213562373095
Fx13_re_a5 0 x13_re_a5 V5 7.0710678118654755
Rp13_re_re_a5 0 x13_re_a5 8.809235095423119e-12
Gp13_re_im_a5 0 x13_re_a5 x13_im_a5 0 123160380596.87326
Cx13_im_a5 x13_im_a5 0 1.0
Gp13_im_re_a5 0 x13_im_a5 x13_re_a5 0 -123160380596.87326
Rp13_im_im_a5 0 x13_im_a5 8.809235095423119e-12
Cx14_a5 x14_a5 0 1.0
Gx14_a5 0 x14_a5 p5 0 0.07071067811865475
Fx14_a5 0 x14_a5 V5 3.5355339059327378
Rp14_a5 0 x14_a5 7.766332233640755e-12
Cx15_a5 x15_a5 0 1.0
Gx15_a5 0 x15_a5 p5 0 0.07071067811865475
Fx15_a5 0 x15_a5 V5 3.5355339059327378
Rp15_a5 0 x15_a5 1.8095221673439617e-11
Cx16_re_a5 x16_re_a5 0 1.0
Gx16_re_a5 0 x16_re_a5 p5 0 0.1414213562373095
Fx16_re_a5 0 x16_re_a5 V5 7.0710678118654755
Rp16_re_re_a5 0 x16_re_a5 1.1460445945124401e-10
Gp16_re_im_a5 0 x16_re_a5 x16_im_a5 0 3105731083.7159095
Cx16_im_a5 x16_im_a5 0 1.0
Gp16_im_re_a5 0 x16_im_a5 x16_re_a5 0 -3105731083.7159095
Rp16_im_im_a5 0 x16_im_a5 1.1460445945124401e-10
*
* Port network for port 6
V6 p6 s6 0
R6 s6 0 50.0
Gd6_1 0 s6 p1 0 -1.2786549450754734e-07
Fd6_1 0 s6 V1 -6.393274725377367e-06
Gr1_6_1 0 s6 x1_a1 0 5190937068185.831
Gr2_re_6_1 0 s6 x2_re_a1 0 -31312704614.40924
Gr2_im_6_1 0 s6 x2_im_a1 0 -109934129367.8407
Gr3_re_6_1 0 s6 x3_re_a1 0 -817556724.96763
Gr3_im_6_1 0 s6 x3_im_a1 0 53980350413.258415
Gr4_re_6_1 0 s6 x4_re_a1 0 484307312551.099
Gr4_im_6_1 0 s6 x4_im_a1 0 158604618420.77222
Gr5_re_6_1 0 s6 x5_re_a1 0 -368939676666.99884
Gr5_im_6_1 0 s6 x5_im_a1 0 -3475120851326.678
Gr6_re_6_1 0 s6 x6_re_a1 0 -11780232838.658558
Gr6_im_6_1 0 s6 x6_im_a1 0 -3747398633.9392457
Gr7_re_6_1 0 s6 x7_re_a1 0 53738059.34333145
Gr7_im_6_1 0 s6 x7_im_a1 0 125617495.40464303
Gr8_6_1 0 s6 x8_a1 0 -19977955204910.65
Gr9_re_6_1 0 s6 x9_re_a1 0 471887319016.5008
Gr9_im_6_1 0 s6 x9_im_a1 0 412139136851.48456
Gr10_6_1 0 s6 x10_a1 0 14873557306966.639
Gr11_6_1 0 s6 x11_a1 0 -1053333548181.3422
Gr12_6_1 0 s6 x12_a1 0 179614521526.25897
Gr13_re_6_1 0 s6 x13_re_a1 0 -2182622677.0203476
Gr13_im_6_1 0 s6 x13_im_a1 0 -1324928787.5526202
Gr14_6_1 0 s6 x14_a1 0 -15559581735.704351
Gr15_6_1 0 s6 x15_a1 0 1633137883.7376642
Gr16_re_6_1 0 s6 x16_re_a1 0 -57938594.83107274
Gr16_im_6_1 0 s6 x16_im_a1 0 -167178955.68522093
Gd6_2 0 s6 p2 0 7.748748111189446e-07
Fd6_2 0 s6 V2 3.874374055594723e-05
Gr1_6_2 0 s6 x1_a2 0 798644133551.8015
Gr2_re_6_2 0 s6 x2_re_a2 0 -74271710305.60222
Gr2_im_6_2 0 s6 x2_im_a2 0 131259702459.24283
Gr3_re_6_2 0 s6 x3_re_a2 0 -11040185016.512093
Gr3_im_6_2 0 s6 x3_im_a2 0 14893279296.656494
Gr4_re_6_2 0 s6 x4_re_a2 0 189695761336.89307
Gr4_im_6_2 0 s6 x4_im_a2 0 11676075443.10197
Gr5_re_6_2 0 s6 x5_re_a2 0 422790881899.9748
Gr5_im_6_2 0 s6 x5_im_a2 0 -951388960034.6378
Gr6_re_6_2 0 s6 x6_re_a2 0 -12517529774.390875
Gr6_im_6_2 0 s6 x6_im_a2 0 12439555695.081354
Gr7_re_6_2 0 s6 x7_re_a2 0 -338720.60517148825
Gr7_im_6_2 0 s6 x7_im_a2 0 45244247.99330822
Gr8_6_2 0 s6 x8_a2 0 -7322422608812.226
Gr9_re_6_2 0 s6 x9_re_a2 0 213754742987.68292
Gr9_im_6_2 0 s6 x9_im_a2 0 358296647756.81494
Gr10_6_2 0 s6 x10_a2 0 5804222793184.435
Gr11_6_2 0 s6 x11_a2 0 -429503694944.7574
Gr12_6_2 0 s6 x12_a2 0 70969450021.3871
Gr13_re_6_2 0 s6 x13_re_a2 0 -781554570.0188892
Gr13_im_6_2 0 s6 x13_im_a2 0 -88203900.01065002
Gr14_6_2 0 s6 x14_a2 0 -4462305542.516587
Gr15_6_2 0 s6 x15_a2 0 392999324.83205146
Gr16_re_6_2 0 s6 x16_re_a2 0 -14656100.625057627
Gr16_im_6_2 0 s6 x16_im_a2 0 -51261894.34963146
Gd6_3 0 s6 p3 0 2.520605077149102e-07
Fd6_3 0 s6 V3 1.2603025385745509e-05
Gr1_6_3 0 s6 x1_a3 0 1016461980295.842
Gr2_re_6_3 0 s6 x2_re_a3 0 -12788566028.613874
Gr2_im_6_3 0 s6 x2_im_a3 0 4577133261.12903
Gr3_re_6_3 0 s6 x3_re_a3 0 13538622872.093725
Gr3_im_6_3 0 s6 x3_im_a3 0 15426118849.079071
Gr4_re_6_3 0 s6 x4_re_a3 0 139131352076.33493
Gr4_im_6_3 0 s6 x4_im_a3 0 32511809950.835094
Gr5_re_6_3 0 s6 x5_re_a3 0 -164733629214.13394
Gr5_im_6_3 0 s6 x5_im_a3 0 -809227828499.9447
Gr6_re_6_3 0 s6 x6_re_a3 0 -22116985881.09806
Gr6_im_6_3 0 s6 x6_im_a3 0 -107138404.05811876
Gr7_re_6_3 0 s6 x7_re_a3 0 16993569.496353783
Gr7_im_6_3 0 s6 x7_im_a3 0 20215231.186324626
Gr8_6_3 0 s6 x8_a3 0 -2630768065432.0776
Gr9_re_6_3 0 s6 x9_re_a3 0 96682407023.2847
Gr9_im_6_3 0 s6 x9_im_a3 0 98686605074.89551
Gr10_6_3 0 s6 x10_a3 0 1752713053253.524
Gr11_6_3 0 s6 x11_a3 0 -81525465953.7605
Gr12_6_3 0 s6 x12_a3 0 5813738135.993163
Gr13_re_6_3 0 s6 x13_re_a3 0 59044586.81325932
Gr13_im_6_3 0 s6 x13_im_a3 0 37673522.635140836
Gr14_6_3 0 s6 x14_a3 0 -100016938.32715923
Gr15_6_3 0 s6 x15_a3 0 89953623.32359591
Gr16_re_6_3 0 s6 x16_re_a3 0 -5088851.101886672
Gr16_im_6_3 0 s6 x16_im_a3 0 -33705986.26963458
Gd6_4 0 s6 p4 0 2.3308428372855945e-07
Fd6_4 0 s6 V4 1.1654214186427973e-05
Gr1_6_4 0 s6 x1_a4 0 1029884753566.593
Gr2_re_6_4 0 s6 x2_re_a4 0 -16005780069.034216
Gr2_im_6_4 0 s6 x2_im_a4 0 1936039867.24661
Gr3_re_6_4 0 s6 x3_re_a4 0 12650752429.397758
Gr3_im_6_4 0 s6 x3_im_a4 0 14726295659.943903
Gr4_re_6_4 0 s6 x4_re_a4 0 137477080757.8532
Gr4_im_6_4 0 s6 x4_im_a4 0 40669872626.874435
Gr5_re_6_4 0 s6 x5_re_a4 0 -124591043986.57883
Gr5_im_6_4 0 s6 x5_im_a4 0 -832524411124.8658
Gr6_re_6_4 0 s6 x6_re_a4 0 -22223697852.514038
Gr6_im_6_4 0 s6 x6_im_a4 0 10639621.89804485
Gr7_re_6_4 0 s6 x7_re_a4 0 12009062.804872023
Gr7_im_6_4 0 s6 x7_im_a4 0 21941282.74938646
Gr8_6_4 0 s6 x8_a4 0 -3190467541517.6377
Gr9_re_6_4 0 s6 x9_re_a4 0 97449361010.69789
Gr9_im_6_4 0 s6 x9_im_a4 0 124537555480.19403
Gr10_6_4 0 s6 x10_a4 0 2277012583202.4844
Gr11_6_4 0 s6 x11_a4 0 -139897900900.21756
Gr12_6_4 0 s6 x12_a4 0 17450987698.10976
Gr13_re_6_4 0 s6 x13_re_a4 0 -110016666.98598853
Gr13_im_6_4 0 s6 x13_im_a4 0 -19564636.685880903
Gr14_6_4 0 s6 x14_a4 0 -1003930546.7330941
Gr15_6_4 0 s6 x15_a4 0 158220275.74493194
Gr16_re_6_4 0 s6 x16_re_a4 0 -6334605.878555852
Gr16_im_6_4 0 s6 x16_im_a4 0 -35485105.20363793
Gd6_5 0 s6 p5 0 -1.1977814910912877e-07
Fd6_5 0 s6 V5 -5.988907455456438e-06
Gr1_6_5 0 s6 x1_a5 0 -880964889258.8043
Gr2_re_6_5 0 s6 x2_re_a5 0 -148772481751.99872
Gr2_im_6_5 0 s6 x2_im_a5 0 -198676771255.74326
Gr3_re_6_5 0 s6 x3_re_a5 0 -42847055566.41394
Gr3_im_6_5 0 s6 x3_im_a5 0 -24783668111.976334
Gr4_re_6_5 0 s6 x4_re_a5 0 -74418489616.74991
Gr4_im_6_5 0 s6 x4_im_a5 0 433836611970.20465
Gr5_re_6_5 0 s6 x5_re_a5 0 2493135314439.0195
Gr5_im_6_5 0 s6 x5_im_a5 0 -663347469044.7988
Gr6_re_6_5 0 s6 x6_re_a5 0 -20662486745.873116
Gr6_im_6_5 0 s6 x6_im_a5 0 10672014283.085133
Gr7_re_6_5 0 s6 x7_re_a5 0 -225483124.43222347
Gr7_im_6_5 0 s6 x7_im_a5 0 52358065.42758949
Gr8_6_5 0 s6 x8_a5 0 -25323637400660.613
Gr9_re_6_5 0 s6 x9_re_a5 0 -91618337197.66632
Gr9_im_6_5 0 s6 x9_im_a5 0 1099108472947.9724
Gr10_6_5 0 s6 x10_a5 0 24246805629526.234
Gr11_6_5 0 s6 x11_a5 0 -2793095735374.536
Gr12_6_5 0 s6 x12_a5 0 555565109128.4408
Gr13_re_6_5 0 s6 x13_re_a5 0 -8119412207.710295
Gr13_im_6_5 0 s6 x13_im_a5 0 -2487425551.3904424
Gr14_6_5 0 s6 x14_a5 0 -42085265478.45497
Gr15_6_5 0 s6 x15_a5 0 3036452490.611025
Gr16_re_6_5 0 s6 x16_re_a5 0 -51872976.387790285
Gr16_im_6_5 0 s6 x16_im_a5 0 -47679224.99723635
Gd6_6 0 s6 p6 0 4.979534963511779e-07
Fd6_6 0 s6 V6 2.4897674817558894e-05
Gr1_6_6 0 s6 x1_a6 0 -5322534970477.215
Gr2_re_6_6 0 s6 x2_re_a6 0 30953840657.75278
Gr2_im_6_6 0 s6 x2_im_a6 0 137584818156.9269
Gr3_re_6_6 0 s6 x3_re_a6 0 -44258409435.88702
Gr3_im_6_6 0 s6 x3_im_a6 0 -54546988005.020065
Gr4_re_6_6 0 s6 x4_re_a6 0 -356562128965.3904
Gr4_im_6_6 0 s6 x4_im_a6 0 112663207216.80171
Gr5_re_6_6 0 s6 x5_re_a6 0 2203328280303.671
Gr5_im_6_6 0 s6 x5_im_a6 0 1714292335871.1147
Gr6_re_6_6 0 s6 x6_re_a6 0 -23117858582.682655
Gr6_im_6_6 0 s6 x6_im_a6 0 -2876716497.3685374
Gr7_re_6_6 0 s6 x7_re_a6 0 -201324483.0028698
Gr7_im_6_6 0 s6 x7_im_a6 0 -42881806.21734077
Gr8_6_6 0 s6 x8_a6 0 -6359960577071.51
Gr9_re_6_6 0 s6 x9_re_a6 0 -328646833734.44495
Gr9_im_6_6 0 s6 x9_im_a6 0 690906828870.51
Gr10_6_6 0 s6 x10_a6 0 8726865746170.553
Gr11_6_6 0 s6 x11_a6 0 -1396687549956.932
Gr12_6_6 0 s6 x12_a6 0 296315585829.0751
Gr13_re_6_6 0 s6 x13_re_a6 0 -4561033932.699645
Gr13_im_6_6 0 s6 x13_im_a6 0 -911236474.7383822
Gr14_6_6 0 s6 x14_a6 0 -21110091015.156773
Gr15_6_6 0 s6 x15_a6 0 1223285535.586077
Gr16_re_6_6 0 s6 x16_re_a6 0 -3690167.0886072046
Gr16_im_6_6 0 s6 x16_im_a6 0 31827376.572040815
Gd6_7 0 s6 p7 0 1.2822213934171598e-07
Fd6_7 0 s6 V7 6.4111069670858e-06
Gr1_6_7 0 s6 x1_a7 0 682424131601.1096
Gr2_re_6_7 0 s6 x2_re_a7 0 104675605485.78838
Gr2_im_6_7 0 s6 x2_im_a7 0 -110278311563.08891
Gr3_re_6_7 0 s6 x3_re_a7 0 3220140609.0652175
Gr3_im_6_7 0 s6 x3_im_a7 0 -2100923474.7582011
Gr4_re_6_7 0 s6 x4_re_a7 0 -184473279141.43082
Gr4_im_6_7 0 s6 x4_im_a7 0 -180793787833.52686
Gr5_re_6_7 0 s6 x5_re_a7 0 -1209253420994.9404
Gr5_im_6_7 0 s6 x5_im_a7 0 1117114878988.7231
Gr6_re_6_7 0 s6 x6_re_a7 0 -21718013785.903492
Gr6_im_6_7 0 s6 x6_im_a7 0 -8604626863.229433
Gr7_re_6_7 0 s6 x7_re_a7 0 73655010.11855607
Gr7_im_6_7 0 s6 x7_im_a7 0 -59105007.69916364
Gr8_6_7 0 s6 x8_a7 0 14931885614401.713
Gr9_re_6_7 0 s6 x9_re_a7 0 -122359950936.0378
Gr9_im_6_7 0 s6 x9_im_a7 0 -657486169643.9016
Gr10_6_7 0 s6 x10_a7 0 -13233407963603.822
Gr11_6_7 0 s6 x11_a7 0 1337619825719.5571
Gr12_6_7 0 s6 x12_a7 0 -252258237135.57288
Gr13_re_6_7 0 s6 x13_re_a7 0 3468324090.792423
Gr13_im_6_7 0 s6 x13_im_a7 0 1052765049.8860878
Gr14_6_7 0 s6 x14_a7 0 18779384803.700623
Gr15_6_7 0 s6 x15_a7 0 -1475595783.1762114
Gr16_re_6_7 0 s6 x16_re_a7 0 31315805.919304896
Gr16_im_6_7 0 s6 x16_im_a7 0 74694171.98133379
Gd6_8 0 s6 p8 0 1.2938778511939475e-07
Fd6_8 0 s6 V8 6.4693892559697375e-06
Gr1_6_8 0 s6 x1_a8 0 663532193452.5624
Gr2_re_6_8 0 s6 x2_re_a8 0 102410649292.38814
Gr2_im_6_8 0 s6 x2_im_a8 0 -110197724630.49005
Gr3_re_6_8 0 s6 x3_re_a8 0 3328459769.6606092
Gr3_im_6_8 0 s6 x3_im_a8 0 -1777487353.3774614
Gr4_re_6_8 0 s6 x4_re_a8 0 -184260495210.11835
Gr4_im_6_8 0 s6 x4_im_a8 0 -180212610897.87848
Gr5_re_6_8 0 s6 x5_re_a8 0 -1205729105910.6965
Gr5_im_6_8 0 s6 x5_im_a8 0 1127810051428.2493
Gr6_re_6_8 0 s6 x6_re_a8 0 -21730095222.46114
Gr6_im_6_8 0 s6 x6_im_a8 0 -8622835997.04878
Gr7_re_6_8 0 s6 x7_re_a8 0 72921714.33945525
Gr7_im_6_8 0 s6 x7_im_a8 0 -58767103.28802058
Gr8_6_8 0 s6 x8_a8 0 14978440026388.176
Gr9_re_6_8 0 s6 x9_re_a8 0 -123285299735.92851
Gr9_im_6_8 0 s6 x9_im_a8 0 -658495045243.896
Gr10_6_8 0 s6 x10_a8 0 -13266245386334.812
Gr11_6_8 0 s6 x11_a8 0 1339620009339.1125
Gr12_6_8 0 s6 x12_a8 0 -252544197461.57864
Gr13_re_6_8 0 s6 x13_re_a8 0 3471601049.4777007
Gr13_im_6_8 0 s6 x13_im_a8 0 1052956459.6286172
Gr14_6_8 0 s6 x14_a8 0 18794075529.51893
Gr15_6_8 0 s6 x15_a8 0 -1476171028.8152852
Gr16_re_6_8 0 s6 x16_re_a8 0 31270725.880741246
Gr16_im_6_8 0 s6 x16_im_a8 0 74460852.52902602
*
* State networks driven by port 6
Cx1_a6 x1_a6 0 1.0
Gx1_a6 0 x1_a6 p6 0 0.07071067811865475
Fx1_a6 0 x1_a6 V6 3.5355339059327378
Rp1_a6 0 x1_a6 1.2667707539388034e-13
Cx2_re_a6 x2_re_a6 0 1.0
Gx2_re_a6 0 x2_re_a6 p6 0 0.1414213562373095
Fx2_re_a6 0 x2_re_a6 V6 7.0710678118654755
Rp2_re_re_a6 0 x2_re_a6 9.289804648696368e-13
Gp2_re_im_a6 0 x2_re_a6 x2_im_a6 0 3958398257259.3657
Cx2_im_a6 x2_im_a6 0 1.0
Gp2_im_re_a6 0 x2_im_a6 x2_re_a6 0 -3958398257259.3657
Rp2_im_im_a6 0 x2_im_a6 9.289804648696368e-13
Cx3_re_a6 x3_re_a6 0 1.0
Gx3_re_a6 0 x3_re_a6 p6 0 0.1414213562373095
Fx3_re_a6 0 x3_re_a6 V6 7.0710678118654755
Rp3_re_re_a6 0 x3_re_a6 1.8873881915204676e-12
Gp3_re_im_a6 0 x3_re_a6 x3_im_a6 0 3441166588437.5947
Cx3_im_a6 x3_im_a6 0 1.0
Gp3_im_re_a6 0 x3_im_a6 x3_re_a6 0 -3441166588437.5947
Rp3_im_im_a6 0 x3_im_a6 1.8873881915204676e-12
Cx4_re_a6 x4_re_a6 0 1.0
Gx4_re_a6 0 x4_re_a6 p6 0 0.1414213562373095
Fx4_re_a6 0 x4_re_a6 V6 7.0710678118654755
Rp4_re_re_a6 0 x4_re_a6 9.922592044099783e-13
Gp4_re_im_a6 0 x4_re_a6 x4_im_a6 0 3220889250610.056
Cx4_im_a6 x4_im_a6 0 1.0
Gp4_im_re_a6 0 x4_im_a6 x4_re_a6 0 -3220889250610.056
Rp4_im_im_a6 0 x4_im_a6 9.922592044099783e-13
Cx5_re_a6 x5_re_a6 0 1.0
Gx5_re_a6 0 x5_re_a6 p6 0 0.1414213562373095
Fx5_re_a6 0 x5_re_a6 V6 7.0710678118654755
Rp5_re_re_a6 0 x5_re_a6 4.2837375484112484e-13
Gp5_re_im_a6 0 x5_re_a6 x5_im_a6 0 2073506969966.306
Cx5_im_a6 x5_im_a6 0 1.0
Gp5_im_re_a6 0 x5_im_a6 x5_re_a6 0 -2073506969966.306
Rp5_im_im_a6 0 x5_im_a6 4.2837375484112484e-13
Cx6_re_a6 x6_re_a6 0 1.0
Gx6_re_a6 0 x6_re_a6 p6 0 0.1414213562373095
Fx6_re_a6 0 x6_re_a6 V6 7.0710678118654755
Rp6_re_re_a6 0 x6_re_a6 2.8457065637511862e-12
Gp6_re_im_a6 0 x6_re_a6 x6_im_a6 0 2302996887167.347
Cx6_im_a6 x6_im_a6 0 1.0
Gp6_im_re_a6 0 x6_im_a6 x6_re_a6 0 -2302996887167.347
Rp6_im_im_a6 0 x6_im_a6 2.8457065637511862e-12
Cx7_re_a6 x7_re_a6 0 1.0
Gx7_re_a6 0 x7_re_a6 p6 0 0.1414213562373095
Fx7_re_a6 0 x7_re_a6 V6 7.0710678118654755
Rp7_re_re_a6 0 x7_re_a6 1.764884203986438e-11
Gp7_re_im_a6 0 x7_re_a6 x7_im_a6 0 1893361683671.1223
Cx7_im_a6 x7_im_a6 0 1.0
Gp7_im_re_a6 0 x7_im_a6 x7_re_a6 0 -1893361683671.1223
Rp7_im_im_a6 0 x7_im_a6 1.764884203986438e-11
Cx8_a6 x8_a6 0 1.0
Gx8_a6 0 x8_a6 p6 0 0.07071067811865475
Fx8_a6 0 x8_a6 V6 3.5355339059327378
Rp8_a6 0 x8_a6 7.134017483278191e-13
Cx9_re_a6 x9_re_a6 0 1.0
Gx9_re_a6 0 x9_re_a6 p6 0 0.1414213562373095
Fx9_re_a6 0 x9_re_a6 V6 7.0710678118654755
Rp9_re_re_a6 0 x9_re_a6 1.1810108382102504e-12
Gp9_re_im_a6 0 x9_re_a6 x9_im_a6 0 667262162732.5848
Cx9_im_a6 x9_im_a6 0 1.0
Gp9_im_re_a6 0 x9_im_a6 x9_re_a6 0 -667262162732.5848
Rp9_im_im_a6 0 x9_im_a6 1.1810108382102504e-12
Cx10_a6 x10_a6 0 1.0
Gx10_a6 0 x10_a6 p6 0 0.07071067811865475
Fx10_a6 0 x10_a6 V6 3.5355339059327378
Rp10_a6 0 x10_a6 9.059895014373575e-13
Cx11_a6 x11_a6 0 1.0
Gx11_a6 0 x11_a6 p6 0 0.07071067811865475
Fx11_a6 0 x11_a6 V6 3.5355339059327378
Rp11_a6 0 x11_a6 1.7461165062812219e-12
Cx12_a6 x12_a6 0 1.0
Gx12_a6 0 x12_a6 p6 0 0.07071067811865475
Fx12_a6 0 x12_a6 V6 3.5355339059327378
Rp12_a6 0 x12_a6 2.9716792303835088e-12
Cx13_re_a6 x13_re_a6 0 1.0
Gx13_re_a6 0 x13_re_a6 p6 0 0.1414213562373095
Fx13_re_a6 0 x13_re_a6 V6 7.0710678118654755
Rp13_re_re_a6 0 x13_re_a6 8.809235095423119e-12
Gp13_re_im_a6 0 x13_re_a6 x13_im_a6 0 123160380596.87326
Cx13_im_a6 x13_im_a6 0 1.0
Gp13_im_re_a6 0 x13_im_a6 x13_re_a6 0 -123160380596.87326
Rp13_im_im_a6 0 x13_im_a6 8.809235095423119e-12
Cx14_a6 x14_a6 0 1.0
Gx14_a6 0 x14_a6 p6 0 0.07071067811865475
Fx14_a6 0 x14_a6 V6 3.5355339059327378
Rp14_a6 0 x14_a6 7.766332233640755e-12
Cx15_a6 x15_a6 0 1.0
Gx15_a6 0 x15_a6 p6 0 0.07071067811865475
Fx15_a6 0 x15_a6 V6 3.5355339059327378
Rp15_a6 0 x15_a6 1.8095221673439617e-11
Cx16_re_a6 x16_re_a6 0 1.0
Gx16_re_a6 0 x16_re_a6 p6 0 0.1414213562373095
Fx16_re_a6 0 x16_re_a6 V6 7.0710678118654755
Rp16_re_re_a6 0 x16_re_a6 1.1460445945124401e-10
Gp16_re_im_a6 0 x16_re_a6 x16_im_a6 0 3105731083.7159095
Cx16_im_a6 x16_im_a6 0 1.0
Gp16_im_re_a6 0 x16_im_a6 x16_re_a6 0 -3105731083.7159095
Rp16_im_im_a6 0 x16_im_a6 1.1460445945124401e-10
*
* Port network for port 7
V7 p7 s7 0
R7 s7 0 50.0
Gd7_1 0 s7 p1 0 1.4477851229795573e-07
Fd7_1 0 s7 V1 7.2389256148977865e-06
Gr1_7_1 0 s7 x1_a1 0 1055417969466.0461
Gr2_re_7_1 0 s7 x2_re_a1 0 -15001525807.931376
Gr2_im_7_1 0 s7 x2_im_a1 0 -66565052256.86028
Gr3_re_7_1 0 s7 x3_re_a1 0 -811256102.6962968
Gr3_im_7_1 0 s7 x3_im_a1 0 4707479282.089254
Gr4_re_7_1 0 s7 x4_re_a1 0 81892780535.18277
Gr4_im_7_1 0 s7 x4_im_a1 0 111341539574.82468
Gr5_re_7_1 0 s7 x5_re_a1 0 162409345241.10904
Gr5_im_7_1 0 s7 x5_im_a1 0 -832157925792.9979
Gr6_re_7_1 0 s7 x6_re_a1 0 -24227811377.832886
Gr6_im_7_1 0 s7 x6_im_a1 0 -5322056756.755793
Gr7_re_7_1 0 s7 x7_re_a1 0 -29100599.320078164
Gr7_im_7_1 0 s7 x7_im_a1 0 24921513.698398292
Gr8_7_1 0 s7 x8_a1 0 -6912158605522.894
Gr9_re_7_1 0 s7 x9_re_a1 0 79365832645.78238
Gr9_im_7_1 0 s7 x9_im_a1 0 309657896416.2502
Gr10_7_1 0 s7 x10_a1 0 5931558444005.068
Gr11_7_1 0 s7 x11_a1 0 -574338415942.5482
Gr12_7_1 0 s7 x12_a1 0 104618471380.84363
Gr13_re_7_1 0 s7 x13_re_a1 0 -1395260072.254091
Gr13_im_7_1 0 s7 x13_im_a1 0 -377047485.4968261
Gr14_7_1 0 s7 x14_a1 0 -7405937654.737762
Gr15_7_1 0 s7 x15_a1 0 585302098.0748442
Gr16_re_7_1 0 s7 x16_re_a1 0 -11295611.617590668
Gr16_im_7_1 0 s7 x16_im_a1 0 -27134338.98011342
Gd7_2 0 s7 p2 0 1.0298092696044147e-07
Fd7_2 0 s7 V2 5.149046348022074e-06
Gr1_7_2 0 s7 x1_a2 0 2565794702122.8936
Gr2_re_7_2 0 s7 x2_re_a2 0 -99014244020.87122
Gr2_im_7_2 0 s7 x2_im_a2 0 -72440109952.29337
Gr3_re_7_2 0 s7 x3_re_a2 0 2137886520.0025806
Gr3_im_7_2 0 s7 x3_im_a2 0 10055744822.570414
Gr4_re_7_2 0 s7 x4_re_a2 0 12687344976.440014
Gr4_im_7_2 0 s7 x4_im_a2 0 -46680756226.872826
Gr5_re_7_2 0 s7 x5_re_a2 0 -707454569595.2872
Gr5_im_7_2 0 s7 x5_im_a2 0 -128415280160.51709
Gr6_re_7_2 0 s7 x6_re_a2 0 -16021474871.845083
Gr6_im_7_2 0 s7 x6_im_a2 0 15491733042.509945
Gr7_re_7_2 0 s7 x7_re_a2 0 44047485.44599966
Gr7_im_7_2 0 s7 x7_im_a2 0 -8922424.253165895
Gr8_7_2 0 s7 x8_a2 0 4430846801623.661
Gr9_re_7_2 0 s7 x9_re_a2 0 -42954610835.66398
Gr9_im_7_2 0 s7 x9_im_a2 0 -208268269641.9069
Gr10_7_2 0 s7 x10_a2 0 -4366058687153.8984
Gr11_7_2 0 s7 x11_a2 0 458833666459.30426
Gr12_7_2 0 s7 x12_a2 0 -104061557033.53543
Gr13_re_7_2 0 s7 x13_re_a2 0 1486390719.099503
Gr13_im_7_2 0 s7 x13_im_a2 0 490807686.5005497
Gr14_7_2 0 s7 x14_a2 0 7732086874.497359
Gr15_7_2 0 s7 x15_a2 0 -617010169.4316708
Gr16_re_7_2 0 s7 x16_re_a2 0 12352222.286203118
Gr16_im_7_2 0 s7 x16_im_a2 0 10448961.581163473
Gd7_3 0 s7 p3 0 2.5803729011871295e-07
Fd7_3 0 s7 V3 1.2901864505935647e-05
Gr1_7_3 0 s7 x1_a3 0 591051369485.7051
Gr2_re_7_3 0 s7 x2_re_a3 0 -55839924507.58742
Gr2_im_7_3 0 s7 x2_im_a3 0 -89523374528.00916
Gr3_re_7_3 0 s7 x3_re_a3 0 -26245406596.28204
Gr3_im_7_3 0 s7 x3_im_a3 0 107214973950.1675
Gr4_re_7_3 0 s7 x4_re_a3 0 -16530672120.4906
Gr4_im_7_3 0 s7 x4_im_a3 0 -293603296070.71814
Gr5_re_7_3 0 s7 x5_re_a3 0 472284930041.14764
Gr5_im_7_3 0 s7 x5_im_a3 0 21287782175.0874
Gr6_re_7_3 0 s7 x6_re_a3 0 -31166404636.82374
Gr6_im_7_3 0 s7 x6_im_a3 0 3178304015.8331037
Gr7_re_7_3 0 s7 x7_re_a3 0 -3060881490.0539913
Gr7_im_7_3 0 s7 x7_im_a3 0 227145277.62404102
Gr8_7_3 0 s7 x8_a3 0 -3564673055614.2803
Gr9_re_7_3 0 s7 x9_re_a3 0 10822963966.012264
Gr9_im_7_3 0 s7 x9_im_a3 0 66440416793.97643
Gr10_7_3 0 s7 x10_a3 0 2377539706988.3374
Gr11_7_3 0 s7 x11_a3 0 -27534367088.346985
Gr12_7_3 0 s7 x12_a3 0 30452880267.801662
Gr13_re_7_3 0 s7 x13_re_a3 0 -387618203.12052155
Gr13_im_7_3 0 s7 x13_im_a3 0 -139561013.77680725
Gr14_7_3 0 s7 x14_a3 0 -1951192383.8958375
Gr15_7_3 0 s7 x15_a3 0 187265933.5950637
Gr16_re_7_3 0 s7 x16_re_a3 0 -694475.3334564939
Gr16_im_7_3 0 s7 x16_im_a3 0 -12405508.59686866
Gd7_4 0 s7 p4 0 1.635894625035515e-07
Fd7_4 0 s7 V4 8.179473125177576e-06
Gr1_7_4 0 s7 x1_a4 0 -95894751465.13127
Gr2_re_7_4 0 s7 x2_re_a4 0 -127885872045.21074
Gr2_im_7_4 0 s7 x2_im_a4 0 -120198784762.50807
Gr3_re_7_4 0 s7 x3_re_a4 0 24737637611.687523
Gr3_im_7_4 0 s7 x3_im_a4 0 -99752800887.27397
Gr4_re_7_4 0 s7 x4_re_a4 0 35933731555.22795
Gr4_im_7_4 0 s7 x4_im_a4 0 361075547285.3208
Gr5_re_7_4 0 s7 x5_re_a4 0 -115075666217.05144
Gr5_im_7_4 0 s7 x5_im_a4 0 94973168303.40909
Gr6_re_7_4 0 s7 x6_re_a4 0 -31166727929.364925
Gr6_im_7_4 0 s7 x6_im_a4 0 3081038054.177623
Gr7_re_7_4 0 s7 x7_re_a4 0 3053737012.221628
Gr7_im_7_4 0 s7 x7_im_a4 0 -212418240.32317215
Gr8_7_4 0 s7 x8_a4 0 473857079669.4967
Gr9_re_7_4 0 s7 x9_re_a4 0 -22422047119.158424
Gr9_im_7_4 0 s7 x9_im_a4 0 59088028233.1184
Gr10_7_4 0 s7 x10_a4 0 299106725468.60004
Gr11_7_4 0 s7 x11_a4 0 -198019544429.2019
Gr12_7_4 0 s7 x12_a4 0 21797359780.83043
Gr13_re_7_4 0 s7 x13_re_a4 0 -345200762.76824474
Gr13_im_7_4 0 s7 x13_im_a4 0 -119506664.17276667
Gr14_7_4 0 s7 x14_a4 0 -1955855518.9455466
Gr15_7_4 0 s7 x15_a4 0 132288623.50735481
Gr16_re_7_4 0 s7 x16_re_a4 0 -5891319.9080333
Gr16_im_7_4 0 s7 x16_im_a4 0 -11847678.791012071
Gd7_5 0 s7 p5 0 2.530158868285781e-07
Fd7_5 0 s7 V5 1.2650794341428906e-05
Gr1_7_5 0 s7 x1_a5 0 -433272129271.0087
Gr2_re_7_5 0 s7 x2_re_a5 0 24000029664.156708
Gr2_im_7_5 0 s7 x2_im_a5 0 97694416634.58873
Gr3_re_7_5 0 s7 x3_re_a5 0 14646915545.784922
Gr3_im_7_5 0 s7 x3_im_a5 0 4838996177.322299
Gr4_re_7_5 0 s7 x4_re_a5 0 -8204828488.153956
Gr4_im_7_5 0 s7 x4_im_a5 0 -60933565030.1507
Gr5_re_7_5 0 s7 x5_re_a5 0 -577032069110.3854
Gr5_im_7_5 0 s7 x5_im_a5 0 473044474051.9977
Gr6_re_7_5 0 s7 x6_re_a5 0 -19588236223.57625
Gr6_im_7_5 0 s7 x6_im_a5 0 6138963482.809605
Gr7_re_7_5 0 s7 x7_re_a5 0 48739794.776967324
Gr7_im_7_5 0 s7 x7_im_a5 0 -22276036.45972204
Gr8_7_5 0 s7 x8_a5 0 8289965204286.83
Gr9_re_7_5 0 s7 x9_re_a5 0 11609161983.091047
Gr9_im_7_5 0 s7 x9_im_a5 0 -366771515565.99475
Gr10_7_5 0 s7 x10_a5 0 -7467813282316.45
Gr11_7_5 0 s7 x11_a5 0 838215950216.2018
Gr12_7_5 0 s7 x12_a5 0 -151383908423.92017
Gr13_re_7_5 0 s7 x13_re_a5 0 2173305042.69906
Gr13_im_7_5 0 s7 x13_im_a5 0 650222373.8182839
Gr14_7_5 0 s7 x14_a5 0 11732784293.710945
Gr15_7_5 0 s7 x15_a5 0 -837479863.1912585
Gr16_re_7_5 0 s7 x16_re_a5 0 17022110.803158954
Gr16_im_7_5 0 s7 x16_im_a5 0 35813223.296458706
Gd7_6 0 s7 p6 0 1.2822213934171598e-07
Fd7_6 0 s7 V6 6.4111069670858e-06
Gr1_7_6 0 s7 x1_a6 0 682424131601.111
Gr2_re_7_6 0 s7 x2_re_a6 0 104675605485.7815
Gr2_im_7_6 0 s7 x2_im_a6 0 -110278311563.08371
Gr3_re_7_6 0 s7 x3_re_a6 0 3220140609.0647025
Gr3_im_7_6 0 s7 x3_im_a6 0 -2100923474.7574847
Gr4_re_7_6 0 s7 x4_re_a6 0 -184473279141.4238
Gr4_im_7_6 0 s7 x4_im_a6 0 -180793787833.51944
Gr5_re_7_6 0 s7 x5_re_a6 0 -1209253420994.8967
Gr5_im_7_6 0 s7 x5_im_a6 0 1117114878988.6787
Gr6_re_7_6 0 s7 x6_re_a6 0 -21718013785.90355
Gr6_im_7_6 0 s7 x6_im_a6 0 -8604626863.229208
Gr7_re_7_6 0 s7 x7_re_a6 0 73655010.11854443
Gr7_im_7_6 0 s7 x7_im_a6 0 -59105007.69917152
Gr8_7_6 0 s7 x8_a6 0 14931885614401.24
Gr9_re_7_6 0 s7 x9_re_a6 0 -122359950936.02922
Gr9_im_7_6 0 s7 x9_im_a6 0 -657486169643.8794
Gr10_7_6 0 s7 x10_a6 0 -13233407963603.422
Gr11_7_6 0 s7 x11_a6 0 1337619825719.5369
Gr12_7_6 0 s7 x12_a6 0 -252258237135.57297
Gr13_re_7_6 0 s7 x13_re_a6 0 3468324090.7926507
Gr13_im_7_6 0 s7 x13_im_a6 0 1052765049.8859533
Gr14_7_6 0 s7 x14_a6 0 18779384803.699944
Gr15_7_6 0 s7 x15_a6 0 -1475595783.1759694
Gr16_re_7_6 0 s7 x16_re_a6 0 31315805.91927017
Gr16_im_7_6 0 s7 x16_im_a6 0 74694171.98136558
Gd7_7 0 s7 p7 0 -2.3655012651446763e-07
Fd7_7 0 s7 V7 -1.1827506325723382e-05
Gr1_7_7 0 s7 x1_a7 0 -4626116384912.584
Gr2_re_7_7 0 s7 x2_re_a7 0 -3522210498.6690116
Gr2_im_7_7 0 s7 x2_im_a7 0 171415658113.1277
Gr3_re_7_7 0 s7 x3_re_a7 0 -142325085582.35123
Gr3_im_7_7 0 s7 x3_im_a7 0 98549472591.20197
Gr4_re_7_7 0 s7 x4_re_a7 0 239106688208.29956
Gr4_im_7_7 0 s7 x4_im_a7 0 210555469086.43054
Gr5_re_7_7 0 s7 x5_re_a7 0 1512349508162.9558
Gr5_im_7_7 0 s7 x5_im_a7 0 -15674280082.452234
Gr6_re_7_7 0 s7 x6_re_a7 0 -29917208438.757164
Gr6_im_7_7 0 s7 x6_im_a7 0 -3687334459.5917177
Gr7_re_7_7 0 s7 x7_re_a7 0 -3031432554.2160206
Gr7_im_7_7 0 s7 x7_im_a7 0 -569194637.7025276
Gr8_7_7 0 s7 x8_a7 0 2287991391532.45
Gr9_re_7_7 0 s7 x9_re_a7 0 -2717766813.3417635
Gr9_im_7_7 0 s7 x9_im_a7 0 -57966578123.14309
Gr10_7_7 0 s7 x10_a7 0 -1851397103982.0508
Gr11_7_7 0 s7 x11_a7 0 4817359925.464571
Gr12_7_7 0 s7 x12_a7 0 -30868748756.891933
Gr13_re_7_7 0 s7 x13_re_a7 0 424264696.3357415
Gr13_im_7_7 0 s7 x13_im_a7 0 195907947.3855712
Gr14_7_7 0 s7 x14_a7 0 1750275758.8820276
Gr15_7_7 0 s7 x15_a7 0 -276151425.7114079
Gr16_re_7_7 0 s7 x16_re_a7 0 -557172.4742199365
Gr16_im_7_7 0 s7 x16_im_a7 0 12077551.196843395
Gd7_8 0 s7 p8 0 5.600995505417038e-07
Fd7_8 0 s7 V8 2.8004977527085192e-05
Gr1_7_8 0 s7 x1_a8 0 3261440610789.501
Gr2_re_7_8 0 s7 x2_re_a8 0 145342442487.13342
Gr2_im_7_8 0 s7 x2_im_a8 0 -110606441779.48698
Gr3_re_7_8 0 s7 x3_re_a8 0 143037194140.00946
Gr3_im_7_8 0 s7 x3_im_a8 0 -91868371782.57304
Gr4_re_7_8 0 s7 x4_re_a8 0 -212725615974.88757
Gr4_im_7_8 0 s7 x4_im_a8 0 -298289368588.1386
Gr5_re_7_8 0 s7 x5_re_a8 0 -1082996263578.0414
Gr5_im_7_8 0 s7 x5_im_a8 0 512244814865.9569
Gr6_re_7_8 0 s7 x6_re_a8 0 -30086949722.15192
Gr6_im_7_8 0 s7 x6_im_a8 0 -3828627246.448388
Gr7_re_7_8 0 s7 x7_re_a8 0 3048467488.3434744
Gr7_im_7_8 0 s7 x7_im_a8 0 570650501.0658398
Gr8_7_8 0 s7 x8_a8 0 -184651843034.676
Gr9_re_7_8 0 s7 x9_re_a8 0 35473659205.96945
Gr9_im_7_8 0 s7 x9_im_a8 0 -25005441897.38218
Gr10_7_8 0 s7 x10_a8 0 -18536533097.015743
Gr11_7_8 0 s7 x11_a8 0 175892341599.05432
Gr12_7_8 0 s7 x12_a8 0 -20328631160.4275
Gr13_re_7_8 0 s7 x13_re_a8 0 384599960.03267187
Gr13_im_7_8 0 s7 x13_im_a8 0 185269138.33620656
Gr14_7_8 0 s7 x14_a8 0 2597183339.8595066
Gr15_7_8 0 s7 x15_a8 0 -101740504.68062821
Gr16_re_7_8 0 s7 x16_re_a8 0 5878794.266737381
Gr16_im_7_8 0 s7 x16_im_a8 0 13227412.432246614
*
* State networks driven by port 7
Cx1_a7 x1_a7 0 1.0
Gx1_a7 0 x1_a7 p7 0 0.07071067811865475
Fx1_a7 0 x1_a7 V7 3.5355339059327378
Rp1_a7 0 x1_a7 1.2667707539388034e-13
Cx2_re_a7 x2_re_a7 0 1.0
Gx2_re_a7 0 x2_re_a7 p7 0 0.1414213562373095
Fx2_re_a7 0 x2_re_a7 V7 7.0710678118654755
Rp2_re_re_a7 0 x2_re_a7 9.289804648696368e-13
Gp2_re_im_a7 0 x2_re_a7 x2_im_a7 0 3958398257259.3657
Cx2_im_a7 x2_im_a7 0 1.0
Gp2_im_re_a7 0 x2_im_a7 x2_re_a7 0 -3958398257259.3657
Rp2_im_im_a7 0 x2_im_a7 9.289804648696368e-13
Cx3_re_a7 x3_re_a7 0 1.0
Gx3_re_a7 0 x3_re_a7 p7 0 0.1414213562373095
Fx3_re_a7 0 x3_re_a7 V7 7.0710678118654755
Rp3_re_re_a7 0 x3_re_a7 1.8873881915204676e-12
Gp3_re_im_a7 0 x3_re_a7 x3_im_a7 0 3441166588437.5947
Cx3_im_a7 x3_im_a7 0 1.0
Gp3_im_re_a7 0 x3_im_a7 x3_re_a7 0 -3441166588437.5947
Rp3_im_im_a7 0 x3_im_a7 1.8873881915204676e-12
Cx4_re_a7 x4_re_a7 0 1.0
Gx4_re_a7 0 x4_re_a7 p7 0 0.1414213562373095
Fx4_re_a7 0 x4_re_a7 V7 7.0710678118654755
Rp4_re_re_a7 0 x4_re_a7 9.922592044099783e-13
Gp4_re_im_a7 0 x4_re_a7 x4_im_a7 0 3220889250610.056
Cx4_im_a7 x4_im_a7 0 1.0
Gp4_im_re_a7 0 x4_im_a7 x4_re_a7 0 -3220889250610.056
Rp4_im_im_a7 0 x4_im_a7 9.922592044099783e-13
Cx5_re_a7 x5_re_a7 0 1.0
Gx5_re_a7 0 x5_re_a7 p7 0 0.1414213562373095
Fx5_re_a7 0 x5_re_a7 V7 7.0710678118654755
Rp5_re_re_a7 0 x5_re_a7 4.2837375484112484e-13
Gp5_re_im_a7 0 x5_re_a7 x5_im_a7 0 2073506969966.306
Cx5_im_a7 x5_im_a7 0 1.0
Gp5_im_re_a7 0 x5_im_a7 x5_re_a7 0 -2073506969966.306
Rp5_im_im_a7 0 x5_im_a7 4.2837375484112484e-13
Cx6_re_a7 x6_re_a7 0 1.0
Gx6_re_a7 0 x6_re_a7 p7 0 0.1414213562373095
Fx6_re_a7 0 x6_re_a7 V7 7.0710678118654755
Rp6_re_re_a7 0 x6_re_a7 2.8457065637511862e-12
Gp6_re_im_a7 0 x6_re_a7 x6_im_a7 0 2302996887167.347
Cx6_im_a7 x6_im_a7 0 1.0
Gp6_im_re_a7 0 x6_im_a7 x6_re_a7 0 -2302996887167.347
Rp6_im_im_a7 0 x6_im_a7 2.8457065637511862e-12
Cx7_re_a7 x7_re_a7 0 1.0
Gx7_re_a7 0 x7_re_a7 p7 0 0.1414213562373095
Fx7_re_a7 0 x7_re_a7 V7 7.0710678118654755
Rp7_re_re_a7 0 x7_re_a7 1.764884203986438e-11
Gp7_re_im_a7 0 x7_re_a7 x7_im_a7 0 1893361683671.1223
Cx7_im_a7 x7_im_a7 0 1.0
Gp7_im_re_a7 0 x7_im_a7 x7_re_a7 0 -1893361683671.1223
Rp7_im_im_a7 0 x7_im_a7 1.764884203986438e-11
Cx8_a7 x8_a7 0 1.0
Gx8_a7 0 x8_a7 p7 0 0.07071067811865475
Fx8_a7 0 x8_a7 V7 3.5355339059327378
Rp8_a7 0 x8_a7 7.134017483278191e-13
Cx9_re_a7 x9_re_a7 0 1.0
Gx9_re_a7 0 x9_re_a7 p7 0 0.1414213562373095
Fx9_re_a7 0 x9_re_a7 V7 7.0710678118654755
Rp9_re_re_a7 0 x9_re_a7 1.1810108382102504e-12
Gp9_re_im_a7 0 x9_re_a7 x9_im_a7 0 667262162732.5848
Cx9_im_a7 x9_im_a7 0 1.0
Gp9_im_re_a7 0 x9_im_a7 x9_re_a7 0 -667262162732.5848
Rp9_im_im_a7 0 x9_im_a7 1.1810108382102504e-12
Cx10_a7 x10_a7 0 1.0
Gx10_a7 0 x10_a7 p7 0 0.07071067811865475
Fx10_a7 0 x10_a7 V7 3.5355339059327378
Rp10_a7 0 x10_a7 9.059895014373575e-13
Cx11_a7 x11_a7 0 1.0
Gx11_a7 0 x11_a7 p7 0 0.07071067811865475
Fx11_a7 0 x11_a7 V7 3.5355339059327378
Rp11_a7 0 x11_a7 1.7461165062812219e-12
Cx12_a7 x12_a7 0 1.0
Gx12_a7 0 x12_a7 p7 0 0.07071067811865475
Fx12_a7 0 x12_a7 V7 3.5355339059327378
Rp12_a7 0 x12_a7 2.9716792303835088e-12
Cx13_re_a7 x13_re_a7 0 1.0
Gx13_re_a7 0 x13_re_a7 p7 0 0.1414213562373095
Fx13_re_a7 0 x13_re_a7 V7 7.0710678118654755
Rp13_re_re_a7 0 x13_re_a7 8.809235095423119e-12
Gp13_re_im_a7 0 x13_re_a7 x13_im_a7 0 123160380596.87326
Cx13_im_a7 x13_im_a7 0 1.0
Gp13_im_re_a7 0 x13_im_a7 x13_re_a7 0 -123160380596.87326
Rp13_im_im_a7 0 x13_im_a7 8.809235095423119e-12
Cx14_a7 x14_a7 0 1.0
Gx14_a7 0 x14_a7 p7 0 0.07071067811865475
Fx14_a7 0 x14_a7 V7 3.5355339059327378
Rp14_a7 0 x14_a7 7.766332233640755e-12
Cx15_a7 x15_a7 0 1.0
Gx15_a7 0 x15_a7 p7 0 0.07071067811865475
Fx15_a7 0 x15_a7 V7 3.5355339059327378
Rp15_a7 0 x15_a7 1.8095221673439617e-11
Cx16_re_a7 x16_re_a7 0 1.0
Gx16_re_a7 0 x16_re_a7 p7 0 0.1414213562373095
Fx16_re_a7 0 x16_re_a7 V7 7.0710678118654755
Rp16_re_re_a7 0 x16_re_a7 1.1460445945124401e-10
Gp16_re_im_a7 0 x16_re_a7 x16_im_a7 0 3105731083.7159095
Cx16_im_a7 x16_im_a7 0 1.0
Gp16_im_re_a7 0 x16_im_a7 x16_re_a7 0 -3105731083.7159095
Rp16_im_im_a7 0 x16_im_a7 1.1460445945124401e-10
*
* Port network for port 8
V8 p8 s8 0
R8 s8 0 50.0
Gd8_1 0 s8 p1 0 1.9573748108809434e-07
Fd8_1 0 s8 V1 9.786874054404718e-06
Gr1_8_1 0 s8 x1_a1 0 1030763145289.6057
Gr2_re_8_1 0 s8 x2_re_a1 0 -17586277244.73762
Gr2_im_8_1 0 s8 x2_im_a1 0 -67174960992.071976
Gr3_re_8_1 0 s8 x3_re_a1 0 -1020303549.4485499
Gr3_im_8_1 0 s8 x3_im_a1 0 4667248786.766532
Gr4_re_8_1 0 s8 x4_re_a1 0 81535946747.05264
Gr4_im_8_1 0 s8 x4_im_a1 0 113645527618.7312
Gr5_re_8_1 0 s8 x5_re_a1 0 170693636283.40146
Gr5_im_8_1 0 s8 x5_im_a1 0 -820466038626.2483
Gr6_re_8_1 0 s8 x6_re_a1 0 -24242913392.75764
Gr6_im_8_1 0 s8 x6_im_a1 0 -5315782502.693635
Gr7_re_8_1 0 s8 x7_re_a1 0 -27621705.760421634
Gr7_im_8_1 0 s8 x7_im_a1 0 25458913.942948185
Gr8_8_1 0 s8 x8_a1 0 -6897787891409.337
Gr9_re_8_1 0 s8 x9_re_a1 0 78035269859.61237
Gr9_im_8_1 0 s8 x9_im_a1 0 310438486776.0046
Gr10_8_1 0 s8 x10_a1 0 5932744601302.523
Gr11_8_1 0 s8 x11_a1 0 -576977114199.9016
Gr12_8_1 0 s8 x12_a1 0 105345282703.41582
Gr13_re_8_1 0 s8 x13_re_a1 0 -1407841183.529042
Gr13_im_8_1 0 s8 x13_im_a1 0 -383293746.5225803
Gr14_8_1 0 s8 x14_a1 0 -7476685610.389766
Gr15_8_1 0 s8 x15_a1 0 591024720.0635216
Gr16_re_8_1 0 s8 x16_re_a1 0 -11379700.949526958
Gr16_im_8_1 0 s8 x16_im_a1 0 -27265287.062022783
Gd8_2 0 s8 p2 0 1.1102117827756913e-08
Fd8_2 0 s8 V2 5.551058913878457e-07
Gr1_8_2 0 s8 x1_a2 0 2560130709088.8115
Gr2_re_8_2 0 s8 x2_re_a2 0 -98864640824.24594
Gr2_im_8_2 0 s8 x2_im_a2 0 -70835812828.90353
Gr3_re_8_2 0 s8 x3_re_a2 0 2563818915.119332
Gr3_im_8_2 0 s8 x3_im_a2 0 10229080606.921131
Gr4_re_8_2 0 s8 x4_re_a2 0 13221726401.95343
Gr4_im_8_2 0 s8 x4_im_a2 0 -48510845183.748825
Gr5_re_8_2 0 s8 x5_re_a2 0 -710984309733.6862
Gr5_im_8_2 0 s8 x5_im_a2 0 -125087990132.00003
Gr6_re_8_2 0 s8 x6_re_a2 0 -16023325756.626507
Gr6_im_8_2 0 s8 x6_im_a2 0 15461444861.590874
Gr7_re_8_2 0 s8 x7_re_a2 0 44740681.24351674
Gr7_im_8_2 0 s8 x7_im_a2 0 -7986205.927969544
Gr8_8_2 0 s8 x8_a2 0 4489069346949.237
Gr9_re_8_2 0 s8 x9_re_a2 0 -43009768283.45495
Gr9_im_8_2 0 s8 x9_im_a2 0 -210640447013.10815
Gr10_8_2 0 s8 x10_a2 0 -4419570309371.384
Gr11_8_2 0 s8 x11_a2 0 465072082416.33704
Gr12_8_2 0 s8 x12_a2 0 -105387418548.14105
Gr13_re_8_2 0 s8 x13_re_a2 0 1505908947.3478086
Gr13_im_8_2 0 s8 x13_im_a2 0 499037862.68367857
Gr14_8_2 0 s8 x14_a2 0 7845224639.410935
Gr15_8_2 0 s8 x15_a2 0 -626750297.4510732
Gr16_re_8_2 0 s8 x16_re_a2 0 12569340.055321785
Gr16_im_8_2 0 s8 x16_im_a2 0 10856119.168057261
Gd8_3 0 s8 p3 0 1.6433308721537644e-07
Fd8_3 0 s8 V3 8.216654360768821e-06
Gr1_8_3 0 s8 x1_a3 0 -25642647858.069008
Gr2_re_8_3 0 s8 x2_re_a3 0 -120894774762.35551
Gr2_im_8_3 0 s8 x2_im_a3 0 -119999899583.3481
Gr3_re_8_3 0 s8 x3_re_a3 0 24757606086.25202
Gr3_im_8_3 0 s8 x3_im_a3 0 -100412662986.14444
Gr4_re_8_3 0 s8 x4_re_a3 0 35422670257.843346
Gr4_im_8_3 0 s8 x4_im_a3 0 358344847936.76117
Gr5_re_8_3 0 s8 x5_re_a3 0 -123113944024.11395
Gr5_im_8_3 0 s8 x5_im_a3 0 55647360577.73287
Gr6_re_8_3 0 s8 x6_re_a3 0 -31157830236.442738
Gr6_im_8_3 0 s8 x6_im_a3 0 3101511481.3383145
Gr7_re_8_3 0 s8 x7_re_a3 0 3053205050.981441
Gr7_im_8_3 0 s8 x7_im_a3 0 -210326031.13615027
Gr8_8_3 0 s8 x8_a3 0 227770884867.97375
Gr9_re_8_3 0 s8 x9_re_a3 0 -19290797739.28683
Gr9_im_8_3 0 s8 x9_im_a3 0 66724374743.52852
Gr10_8_3 0 s8 x10_a3 0 494403857803.2494
Gr11_8_3 0 s8 x11_a3 0 -214434959140.57828
Gr12_8_3 0 s8 x12_a3 0 24725003037.42946
Gr13_re_8_3 0 s8 x13_re_a3 0 -384283789.12537456
Gr13_im_8_3 0 s8 x13_im_a3 0 -131132645.30081494
Gr14_8_3 0 s8 x14_a3 0 -2165745564.3509846
Gr15_8_3 0 s8 x15_a3 0 148201124.1191206
Gr16_re_8_3 0 s8 x16_re_a3 0 -6216478.7356198635
Gr16_im_8_3 0 s8 x16_im_a3 0 -12544197.258908179
Gd8_4 0 s8 p4 0 3.3282800140689747e-07
Fd8_4 0 s8 V4 1.6641400070344873e-05
Gr1_8_4 0 s8 x1_a4 0 552126289144.1288
Gr2_re_8_4 0 s8 x2_re_a4 0 -57505423374.01206
Gr2_im_8_4 0 s8 x2_im_a4 0 -89357470685.61316
Gr3_re_8_4 0 s8 x3_re_a4 0 -26044412246.45488
Gr3_im_8_4 0 s8 x3_im_a4 0 107429605754.99467
Gr4_re_8_4 0 s8 x4_re_a4 0 -16791289916.34861
Gr4_im_8_4 0 s8 x4_im_a4 0 -294446207470.0416
Gr5_re_8_4 0 s8 x5_re_a4 0 465280734408.0396
Gr5_im_8_4 0 s8 x5_im_a4 0 48546105491.22015
Gr6_re_8_4 0 s8 x6_re_a4 0 -31160871684.605488
Gr6_im_8_4 0 s8 x6_im_a4 0 3121631637.857818
Gr7_re_8_4 0 s8 x7_re_a4 0 -3061166991.1724243
Gr7_im_8_4 0 s8 x7_im_a4 0 225109512.31974941
Gr8_8_4 0 s8 x8_a4 0 -3297334524464.4326
Gr9_re_8_4 0 s8 x9_re_a4 0 8814668088.622572
Gr9_im_8_4 0 s8 x9_im_a4 0 56168028784.66972
Gr10_8_4 0 s8 x10_a4 0 2147074844999.7808
Gr11_8_4 0 s8 x11_a4 0 -5079101413.64443
Gr12_8_4 0 s8 x12_a4 0 26201975903.17439
Gr13_re_8_4 0 s8 x13_re_a4 0 -328620375.99508274
Gr13_im_8_4 0 s8 x13_im_a4 0 -119188332.6503508
Gr14_8_4 0 s8 x14_a4 0 -1625795753.7332728
Gr15_8_4 0 s8 x15_a4 0 161044697.02698383
Gr16_re_8_4 0 s8 x16_re_a4 0 -109350.08135382675
Gr16_im_8_4 0 s8 x16_im_a4 0 -11197407.39211548
Gd8_5 0 s8 p5 0 2.956152009980783e-07
Fd8_5 0 s8 V5 1.4780760049903917e-05
Gr1_8_5 0 s8 x1_a5 0 -448651488417.03375
Gr2_re_8_5 0 s8 x2_re_a5 0 24377287614.051186
Gr2_im_8_5 0 s8 x2_im_a5 0 97135287448.70377
Gr3_re_8_5 0 s8 x3_re_a5 0 14890756105.312418
Gr3_im_8_5 0 s8 x3_im_a5 0 4756396749.6862755
Gr4_re_8_5 0 s8 x4_re_a5 0 -9764572108.311426
Gr4_im_8_5 0 s8 x4_im_a5 0 -62220242289.11162
Gr5_re_8_5 0 s8 x5_re_a5 0 -583234882335.725
Gr5_im_8_5 0 s8 x5_im_a5 0 489683690695.9621
Gr6_re_8_5 0 s8 x6_re_a5 0 -19600019653.65004
Gr6_im_8_5 0 s8 x6_im_a5 0 6102558042.374741
Gr7_re_8_5 0 s8 x7_re_a5 0 50279842.02466854
Gr7_im_8_5 0 s8 x7_im_a5 0 -24072088.276468027
Gr8_8_5 0 s8 x8_a5 0 8429378203496.085
Gr9_re_8_5 0 s8 x9_re_a5 0 10031589084.656624
Gr9_im_8_5 0 s8 x9_im_a5 0 -371829825859.2092
Gr10_8_5 0 s8 x10_a5 0 -7584045613737.269
Gr11_8_5 0 s8 x11_a5 0 848453679697.5416
Gr12_8_5 0 s8 x12_a5 0 -153190438356.90186
Gr13_re_8_5 0 s8 x13_re_a5 0 2197338359.026395
Gr13_im_8_5 0 s8 x13_im_a5 0 656657626.3418765
Gr14_8_5 0 s8 x14_a5 0 11857926183.274605
Gr15_8_5 0 s8 x15_a5 0 -846185369.6184492
Gr16_re_8_5 0 s8 x16_re_a5 0 17162350.561992683
Gr16_im_8_5 0 s8 x16_im_a5 0 35973707.32605916
Gd8_6 0 s8 p6 0 1.2938778511939475e-07
Fd8_6 0 s8 V6 6.4693892559697375e-06
Gr1_8_6 0 s8 x1_a6 0 663532193452.5343
Gr2_re_8_6 0 s8 x2_re_a6 0 102410649292.38734
Gr2_im_8_6 0 s8 x2_im_a6 0 -110197724630.48607
Gr3_re_8_6 0 s8 x3_re_a6 0 3328459769.6611304
Gr3_im_8_6 0 s8 x3_im_a6 0 -1777487353.3770733
Gr4_re_8_6 0 s8 x4_re_a6 0 -184260495210.11554
Gr4_im_8_6 0 s8 x4_im_a6 0 -180212610897.87918
Gr5_re_8_6 0 s8 x5_re_a6 0 -1205729105910.7
Gr5_im_8_6 0 s8 x5_im_a6 0 1127810051428.2517
Gr6_re_8_6 0 s8 x6_re_a6 0 -21730095222.460968
Gr6_im_8_6 0 s8 x6_im_a6 0 -8622835997.04871
Gr7_re_8_6 0 s8 x7_re_a6 0 72921714.33945966
Gr7_im_8_6 0 s8 x7_im_a6 0 -58767103.28808346
Gr8_8_6 0 s8 x8_a6 0 14978440026388.4
Gr9_re_8_6 0 s8 x9_re_a6 0 -123285299735.9205
Gr9_im_8_6 0 s8 x9_im_a6 0 -658495045243.9064
Gr10_8_6 0 s8 x10_a6 0 -13266245386335.102
Gr11_8_6 0 s8 x11_a6 0 1339620009339.1758
Gr12_8_6 0 s8 x12_a6 0 -252544197461.59833
Gr13_re_8_6 0 s8 x13_re_a6 0 3471601049.478284
Gr13_im_8_6 0 s8 x13_im_a6 0 1052956459.6289173
Gr14_8_6 0 s8 x14_a6 0 18794075529.521076
Gr15_8_6 0 s8 x15_a6 0 -1476171028.815324
Gr16_re_8_6 0 s8 x16_re_a6 0 31270725.880736142
Gr16_im_8_6 0 s8 x16_im_a6 0 74460852.5291415
Gd8_7 0 s8 p7 0 5.600995505417038e-07
Fd8_7 0 s8 V7 2.8004977527085192e-05
Gr1_8_7 0 s8 x1_a7 0 3261440610789.498
Gr2_re_8_7 0 s8 x2_re_a7 0 145342442487.1336
Gr2_im_8_7 0 s8 x2_im_a7 0 -110606441779.48676
Gr3_re_8_7 0 s8 x3_re_a7 0 143037194140.00955
Gr3_im_8_7 0 s8 x3_im_a7 0 -91868371782.57294
Gr4_re_8_7 0 s8 x4_re_a7 0 -212725615974.8874
Gr4_im_8_7 0 s8 x4_im_a7 0 -298289368588.1394
Gr5_re_8_7 0 s8 x5_re_a7 0 -1082996263578.0446
Gr5_im_8_7 0 s8 x5_im_a7 0 512244814865.95874
Gr6_re_8_7 0 s8 x6_re_a7 0 -30086949722.1519
Gr6_im_8_7 0 s8 x6_im_a7 0 -3828627246.448403
Gr7_re_8_7 0 s8 x7_re_a7 0 3048467488.343474
Gr7_im_8_7 0 s8 x7_im_a7 0 570650501.0658411
Gr8_8_7 0 s8 x8_a7 0 -184651843034.6251
Gr9_re_8_7 0 s8 x9_re_a7 0 35473659205.96981
Gr9_im_8_7 0 s8 x9_im_a7 0 -25005441897.38457
Gr10_8_7 0 s8 x10_a7 0 -18536533097.06549
Gr11_8_7 0 s8 x11_a7 0 175892341599.06006
Gr12_8_7 0 s8 x12_a7 0 -20328631160.428284
Gr13_re_8_7 0 s8 x13_re_a7 0 384599960.0327008
Gr13_im_8_7 0 s8 x13_im_a7 0 185269138.33617318
Gr14_8_7 0 s8 x14_a7 0 2597183339.8593125
Gr15_8_7 0 s8 x15_a7 0 -101740504.68057323
Gr16_re_8_7 0 s8 x16_re_a7 0 5878794.266738632
Gr16_im_8_7 0 s8 x16_im_a7 0 13227412.432234941
Gd8_8 0 s8 p8 0 -1.3904679079690397e-07
Fd8_8 0 s8 V8 -6.952339539845199e-06
Gr1_8_8 0 s8 x1_a8 0 -4664550854112.788
Gr2_re_8_8 0 s8 x2_re_a8 0 -9705889446.557762
Gr2_im_8_8 0 s8 x2_im_a8 0 170398467992.36584
Gr3_re_8_8 0 s8 x3_re_a8 0 -142675439658.69107
Gr3_im_8_8 0 s8 x3_im_a8 0 99230420242.18143
Gr4_re_8_8 0 s8 x4_re_a8 0 240474388687.55518
Gr4_im_8_8 0 s8 x4_im_a8 0 213979649666.27087
Gr5_re_8_8 0 s8 x5_re_a8 0 1521549916722.3838
Gr5_im_8_8 0 s8 x5_im_a8 0 5120745949.808021
Gr6_re_8_8 0 s8 x6_re_a8 0 -29919423880.782913
Gr6_im_8_8 0 s8 x6_im_a8 0 -3712908276.230975
Gr7_re_8_8 0 s8 x7_re_a8 0 -3032467132.268941
Gr7_im_8_8 0 s8 x7_im_a8 0 -572219486.5744084
Gr8_8_8 0 s8 x8_a8 0 2379211328241.269
Gr9_re_8_8 0 s8 x9_re_a8 0 -4480038158.9224
Gr9_im_8_8 0 s8 x9_im_a8 0 -59942501196.854965
Gr10_8_8 0 s8 x10_a8 0 -1916359281249.7446
Gr11_8_8 0 s8 x11_a8 0 9118514003.595362
Gr12_8_8 0 s8 x12_a8 0 -31572157636.011303
Gr13_re_8_8 0 s8 x13_re_a8 0 432680500.4268931
Gr13_im_8_8 0 s8 x13_im_a8 0 197985573.7612501
Gr14_8_8 0 s8 x14_a8 0 1799086432.2074773
Gr15_8_8 0 s8 x15_a8 0 -280215957.88585037
Gr16_re_8_8 0 s8 x16_re_a8 0 -445602.0473331227
Gr16_im_8_8 0 s8 x16_im_a8 0 12210072.253924057
*
* State networks driven by port 8
Cx1_a8 x1_a8 0 1.0
Gx1_a8 0 x1_a8 p8 0 0.07071067811865475
Fx1_a8 0 x1_a8 V8 3.5355339059327378
Rp1_a8 0 x1_a8 1.2667707539388034e-13
Cx2_re_a8 x2_re_a8 0 1.0
Gx2_re_a8 0 x2_re_a8 p8 0 0.1414213562373095
Fx2_re_a8 0 x2_re_a8 V8 7.0710678118654755
Rp2_re_re_a8 0 x2_re_a8 9.289804648696368e-13
Gp2_re_im_a8 0 x2_re_a8 x2_im_a8 0 3958398257259.3657
Cx2_im_a8 x2_im_a8 0 1.0
Gp2_im_re_a8 0 x2_im_a8 x2_re_a8 0 -3958398257259.3657
Rp2_im_im_a8 0 x2_im_a8 9.289804648696368e-13
Cx3_re_a8 x3_re_a8 0 1.0
Gx3_re_a8 0 x3_re_a8 p8 0 0.1414213562373095
Fx3_re_a8 0 x3_re_a8 V8 7.0710678118654755
Rp3_re_re_a8 0 x3_re_a8 1.8873881915204676e-12
Gp3_re_im_a8 0 x3_re_a8 x3_im_a8 0 3441166588437.5947
Cx3_im_a8 x3_im_a8 0 1.0
Gp3_im_re_a8 0 x3_im_a8 x3_re_a8 0 -3441166588437.5947
Rp3_im_im_a8 0 x3_im_a8 1.8873881915204676e-12
Cx4_re_a8 x4_re_a8 0 1.0
Gx4_re_a8 0 x4_re_a8 p8 0 0.1414213562373095
Fx4_re_a8 0 x4_re_a8 V8 7.0710678118654755
Rp4_re_re_a8 0 x4_re_a8 9.922592044099783e-13
Gp4_re_im_a8 0 x4_re_a8 x4_im_a8 0 3220889250610.056
Cx4_im_a8 x4_im_a8 0 1.0
Gp4_im_re_a8 0 x4_im_a8 x4_re_a8 0 -3220889250610.056
Rp4_im_im_a8 0 x4_im_a8 9.922592044099783e-13
Cx5_re_a8 x5_re_a8 0 1.0
Gx5_re_a8 0 x5_re_a8 p8 0 0.1414213562373095
Fx5_re_a8 0 x5_re_a8 V8 7.0710678118654755
Rp5_re_re_a8 0 x5_re_a8 4.2837375484112484e-13
Gp5_re_im_a8 0 x5_re_a8 x5_im_a8 0 2073506969966.306
Cx5_im_a8 x5_im_a8 0 1.0
Gp5_im_re_a8 0 x5_im_a8 x5_re_a8 0 -2073506969966.306
Rp5_im_im_a8 0 x5_im_a8 4.2837375484112484e-13
Cx6_re_a8 x6_re_a8 0 1.0
Gx6_re_a8 0 x6_re_a8 p8 0 0.1414213562373095
Fx6_re_a8 0 x6_re_a8 V8 7.0710678118654755
Rp6_re_re_a8 0 x6_re_a8 2.8457065637511862e-12
Gp6_re_im_a8 0 x6_re_a8 x6_im_a8 0 2302996887167.347
Cx6_im_a8 x6_im_a8 0 1.0
Gp6_im_re_a8 0 x6_im_a8 x6_re_a8 0 -2302996887167.347
Rp6_im_im_a8 0 x6_im_a8 2.8457065637511862e-12
Cx7_re_a8 x7_re_a8 0 1.0
Gx7_re_a8 0 x7_re_a8 p8 0 0.1414213562373095
Fx7_re_a8 0 x7_re_a8 V8 7.0710678118654755
Rp7_re_re_a8 0 x7_re_a8 1.764884203986438e-11
Gp7_re_im_a8 0 x7_re_a8 x7_im_a8 0 1893361683671.1223
Cx7_im_a8 x7_im_a8 0 1.0
Gp7_im_re_a8 0 x7_im_a8 x7_re_a8 0 -1893361683671.1223
Rp7_im_im_a8 0 x7_im_a8 1.764884203986438e-11
Cx8_a8 x8_a8 0 1.0
Gx8_a8 0 x8_a8 p8 0 0.07071067811865475
Fx8_a8 0 x8_a8 V8 3.5355339059327378
Rp8_a8 0 x8_a8 7.134017483278191e-13
Cx9_re_a8 x9_re_a8 0 1.0
Gx9_re_a8 0 x9_re_a8 p8 0 0.1414213562373095
Fx9_re_a8 0 x9_re_a8 V8 7.0710678118654755
Rp9_re_re_a8 0 x9_re_a8 1.1810108382102504e-12
Gp9_re_im_a8 0 x9_re_a8 x9_im_a8 0 667262162732.5848
Cx9_im_a8 x9_im_a8 0 1.0
Gp9_im_re_a8 0 x9_im_a8 x9_re_a8 0 -667262162732.5848
Rp9_im_im_a8 0 x9_im_a8 1.1810108382102504e-12
Cx10_a8 x10_a8 0 1.0
Gx10_a8 0 x10_a8 p8 0 0.07071067811865475
Fx10_a8 0 x10_a8 V8 3.5355339059327378
Rp10_a8 0 x10_a8 9.059895014373575e-13
Cx11_a8 x11_a8 0 1.0
Gx11_a8 0 x11_a8 p8 0 0.07071067811865475
Fx11_a8 0 x11_a8 V8 3.5355339059327378
Rp11_a8 0 x11_a8 1.7461165062812219e-12
Cx12_a8 x12_a8 0 1.0
Gx12_a8 0 x12_a8 p8 0 0.07071067811865475
Fx12_a8 0 x12_a8 V8 3.5355339059327378
Rp12_a8 0 x12_a8 2.9716792303835088e-12
Cx13_re_a8 x13_re_a8 0 1.0
Gx13_re_a8 0 x13_re_a8 p8 0 0.1414213562373095
Fx13_re_a8 0 x13_re_a8 V8 7.0710678118654755
Rp13_re_re_a8 0 x13_re_a8 8.809235095423119e-12
Gp13_re_im_a8 0 x13_re_a8 x13_im_a8 0 123160380596.87326
Cx13_im_a8 x13_im_a8 0 1.0
Gp13_im_re_a8 0 x13_im_a8 x13_re_a8 0 -123160380596.87326
Rp13_im_im_a8 0 x13_im_a8 8.809235095423119e-12
Cx14_a8 x14_a8 0 1.0
Gx14_a8 0 x14_a8 p8 0 0.07071067811865475
Fx14_a8 0 x14_a8 V8 3.5355339059327378
Rp14_a8 0 x14_a8 7.766332233640755e-12
Cx15_a8 x15_a8 0 1.0
Gx15_a8 0 x15_a8 p8 0 0.07071067811865475
Fx15_a8 0 x15_a8 V8 3.5355339059327378
Rp15_a8 0 x15_a8 1.8095221673439617e-11
Cx16_re_a8 x16_re_a8 0 1.0
Gx16_re_a8 0 x16_re_a8 p8 0 0.1414213562373095
Fx16_re_a8 0 x16_re_a8 V8 7.0710678118654755
Rp16_re_re_a8 0 x16_re_a8 1.1460445945124401e-10
Gp16_re_im_a8 0 x16_re_a8 x16_im_a8 0 3105731083.7159095
Cx16_im_a8 x16_im_a8 0 1.0
Gp16_im_re_a8 0 x16_im_a8 x16_re_a8 0 -3105731083.7159095
Rp16_im_im_a8 0 x16_im_a8 1.1460445945124401e-10
.ENDS s_equivalent90

* EQUIVALENT CIRCUIT FOR VECTOR FITTED S-MATRIX
* Created using scikit-rf vectorFitting.py
*
.SUBCKT Trafo_LO p1 p2 p3 p4 p5 p6 p7 p8
*
* Port network for port 1
V1 p1 s1 0
R1 s1 0 50.0
Gd1_1 0 s1 p1 0 3.352803149636596e-07
Fd1_1 0 s1 V1 1.676401574818298e-05
Gr1_1_1 0 s1 x1_a1 0 -687180402041.8207
Gr2_re_1_1 0 s1 x2_re_a1 0 163259739698.8263
Gr2_im_1_1 0 s1 x2_im_a1 0 13670028099.335598
Gr3_re_1_1 0 s1 x3_re_a1 0 251533738808.68222
Gr3_im_1_1 0 s1 x3_im_a1 0 -196843967440.58936
Gr4_re_1_1 0 s1 x4_re_a1 0 -151059974492.5184
Gr4_im_1_1 0 s1 x4_im_a1 0 -362128623604.6113
Gr5_re_1_1 0 s1 x5_re_a1 0 -11979343225.949139
Gr5_im_1_1 0 s1 x5_im_a1 0 11376633641.286427
Gr6_re_1_1 0 s1 x6_re_a1 0 234707795.95277622
Gr6_im_1_1 0 s1 x6_im_a1 0 442007720.4162643
Gr7_re_1_1 0 s1 x7_re_a1 0 1108300228393.7622
Gr7_im_1_1 0 s1 x7_im_a1 0 58997375303.40927
Gr8_1_1 0 s1 x8_a1 0 -2455639741892.209
Gr9_re_1_1 0 s1 x9_re_a1 0 -257853299633.53424
Gr9_im_1_1 0 s1 x9_im_a1 0 -669433548721.6101
Gr10_1_1 0 s1 x10_a1 0 18413586615.788742
Gr11_re_1_1 0 s1 x11_re_a1 0 -1330193872.1036365
Gr11_im_1_1 0 s1 x11_im_a1 0 -249474408.64154536
Gr12_re_1_1 0 s1 x12_re_a1 0 -163341452.63600335
Gr12_im_1_1 0 s1 x12_im_a1 0 -166816070.69436252
Gd1_2 0 s1 p2 0 1.106369085535075e-07
Fd1_2 0 s1 V2 5.531845427675376e-06
Gr1_1_2 0 s1 x1_a2 0 711127004629.6648
Gr2_re_1_2 0 s1 x2_re_a2 0 26762972959.906334
Gr2_im_1_2 0 s1 x2_im_a2 0 -34689915558.41926
Gr3_re_1_2 0 s1 x3_re_a2 0 181497839590.13922
Gr3_im_1_2 0 s1 x3_im_a2 0 21586561566.997173
Gr4_re_1_2 0 s1 x4_re_a2 0 -33718822461.98181
Gr4_im_1_2 0 s1 x4_im_a2 0 -190309085158.92157
Gr5_re_1_2 0 s1 x5_re_a2 0 -12808940807.053083
Gr5_im_1_2 0 s1 x5_im_a2 0 19007187371.192684
Gr6_re_1_2 0 s1 x6_re_a2 0 161390837.15409228
Gr6_im_1_2 0 s1 x6_im_a2 0 263347412.90720224
Gr7_re_1_2 0 s1 x7_re_a2 0 703743620703.0883
Gr7_im_1_2 0 s1 x7_im_a2 0 14449133451.020128
Gr8_1_2 0 s1 x8_a2 0 -1682721393490.9868
Gr9_re_1_2 0 s1 x9_re_a2 0 -70816762791.76646
Gr9_im_1_2 0 s1 x9_im_a2 0 -500088627117.2996
Gr10_1_2 0 s1 x10_a2 0 12235714994.474062
Gr11_re_1_2 0 s1 x11_re_a2 0 -838915443.7201066
Gr11_im_1_2 0 s1 x11_im_a2 0 -153957299.9626639
Gr12_re_1_2 0 s1 x12_re_a2 0 -102267373.36578907
Gr12_im_1_2 0 s1 x12_im_a2 0 -121496435.22687465
Gd1_3 0 s1 p3 0 1.1070275995694878e-06
Fd1_3 0 s1 V3 5.535137997847439e-05
Gr1_1_3 0 s1 x1_a3 0 857361566080.1837
Gr2_re_1_3 0 s1 x2_re_a3 0 8684947993.165174
Gr2_im_1_3 0 s1 x2_im_a3 0 -15923940731.02358
Gr3_re_1_3 0 s1 x3_re_a3 0 -103916626605.43797
Gr3_im_1_3 0 s1 x3_im_a3 0 -45163661724.14968
Gr4_re_1_3 0 s1 x4_re_a3 0 -30262033967.709293
Gr4_im_1_3 0 s1 x4_im_a3 0 62998036421.640045
Gr5_re_1_3 0 s1 x5_re_a3 0 -33350891465.430595
Gr5_im_1_3 0 s1 x5_im_a3 0 5348976766.903671
Gr6_re_1_3 0 s1 x6_re_a3 0 -41164696.83331084
Gr6_im_1_3 0 s1 x6_im_a3 0 -153219196.53296822
Gr7_re_1_3 0 s1 x7_re_a3 0 -257008931606.5741
Gr7_im_1_3 0 s1 x7_im_a3 0 42973443156.16216
Gr8_1_3 0 s1 x8_a3 0 568368846273.8506
Gr9_re_1_3 0 s1 x9_re_a3 0 45078140106.73188
Gr9_im_1_3 0 s1 x9_im_a3 0 94088277840.39815
Gr10_1_3 0 s1 x10_a3 0 -110888909.68777777
Gr11_re_1_3 0 s1 x11_re_a3 0 -143417952.32611743
Gr11_im_1_3 0 s1 x11_im_a3 0 -128587123.87234186
Gr12_re_1_3 0 s1 x12_re_a3 0 -30890711.39919439
Gr12_im_1_3 0 s1 x12_im_a3 0 -38717187.54706755
Gd1_4 0 s1 p4 0 1.168302145904132e-06
Fd1_4 0 s1 V4 5.841510729520661e-05
Gr1_1_4 0 s1 x1_a4 0 873253897436.2998
Gr2_re_1_4 0 s1 x2_re_a4 0 7573092476.163782
Gr2_im_1_4 0 s1 x2_im_a4 0 -17381753922.134377
Gr3_re_1_4 0 s1 x3_re_a4 0 -104155641823.19228
Gr3_im_1_4 0 s1 x3_im_a4 0 -44430346490.117165
Gr4_re_1_4 0 s1 x4_re_a4 0 -30865975530.606186
Gr4_im_1_4 0 s1 x4_im_a4 0 61283172042.860916
Gr5_re_1_4 0 s1 x5_re_a4 0 -33177692021.947437
Gr5_im_1_4 0 s1 x5_im_a4 0 5460040301.1008005
Gr6_re_1_4 0 s1 x6_re_a4 0 -39349714.868769914
Gr6_im_1_4 0 s1 x6_im_a4 0 -147315730.22818872
Gr7_re_1_4 0 s1 x7_re_a4 0 -244073150360.2265
Gr7_im_1_4 0 s1 x7_im_a4 0 42642330946.74594
Gr8_1_4 0 s1 x8_a4 0 539813955705.0882
Gr9_re_1_4 0 s1 x9_re_a4 0 43024872700.469635
Gr9_im_1_4 0 s1 x9_im_a4 0 86953324642.08044
Gr10_1_4 0 s1 x10_a4 0 132241649.00989011
Gr11_re_1_4 0 s1 x11_re_a4 0 -162669768.50392607
Gr11_im_1_4 0 s1 x11_im_a4 0 -132723808.57227086
Gr12_re_1_4 0 s1 x12_re_a4 0 -32979683.58912554
Gr12_im_1_4 0 s1 x12_im_a4 0 -40661404.564915985
Gd1_5 0 s1 p5 0 3.4628440887226124e-07
Fd1_5 0 s1 V5 1.731422044361306e-05
Gr1_1_5 0 s1 x1_a5 0 382557379978.00543
Gr2_re_1_5 0 s1 x2_re_a5 0 -10586348267.878942
Gr2_im_1_5 0 s1 x2_im_a5 0 6609100857.421646
Gr3_re_1_5 0 s1 x3_re_a5 0 13923877715.751558
Gr3_im_1_5 0 s1 x3_im_a5 0 -100341859927.88783
Gr4_re_1_5 0 s1 x4_re_a5 0 -34773609758.316444
Gr4_im_1_5 0 s1 x4_im_a5 0 158539265941.45255
Gr5_re_1_5 0 s1 x5_re_a5 0 -37673065805.86037
Gr5_im_1_5 0 s1 x5_im_a5 0 -1486687383.7469313
Gr6_re_1_5 0 s1 x6_re_a5 0 -49422169.53508605
Gr6_im_1_5 0 s1 x6_im_a5 0 -291184051.25178987
Gr7_re_1_5 0 s1 x7_re_a5 0 -689255712892.8235
Gr7_im_1_5 0 s1 x7_im_a5 0 -76449687744.49149
Gr8_1_5 0 s1 x8_a5 0 1664206556004.054
Gr9_re_1_5 0 s1 x9_re_a5 0 35130769343.371025
Gr9_im_1_5 0 s1 x9_im_a5 0 513194478951.8262
Gr10_1_5 0 s1 x10_a5 0 -14442973803.051151
Gr11_re_1_5 0 s1 x11_re_a5 0 1036847869.2779258
Gr11_im_1_5 0 s1 x11_im_a5 0 196989436.92684647
Gr12_re_1_5 0 s1 x12_re_a5 0 119317195.20586553
Gr12_im_1_5 0 s1 x12_im_a5 0 116956440.58400036
Gd1_6 0 s1 p6 0 1.3053599760791225e-07
Fd1_6 0 s1 V6 6.526799880395613e-06
Gr1_1_6 0 s1 x1_a6 0 -1678585370675.7656
Gr2_re_1_6 0 s1 x2_re_a6 0 -65162109832.637
Gr2_im_1_6 0 s1 x2_im_a6 0 -57580975183.96362
Gr3_re_1_6 0 s1 x3_re_a6 0 62194693937.00006
Gr3_im_1_6 0 s1 x3_im_a6 0 145075629707.24548
Gr4_re_1_6 0 s1 x4_re_a6 0 42474176202.80471
Gr4_im_1_6 0 s1 x4_im_a6 0 88125111235.73785
Gr5_re_1_6 0 s1 x5_re_a6 0 -28959641169.07143
Gr5_im_1_6 0 s1 x5_im_a6 0 -251181206.88610965
Gr6_re_1_6 0 s1 x6_re_a6 0 -7463085.550565367
Gr6_im_1_6 0 s1 x6_im_a6 0 -111828263.62951487
Gr7_re_1_6 0 s1 x7_re_a6 0 25368827062.071114
Gr7_im_1_6 0 s1 x7_im_a6 0 26374612273.50321
Gr8_1_6 0 s1 x8_a6 0 -53522205499.00157
Gr9_re_1_6 0 s1 x9_re_a6 0 130027854838.61195
Gr9_im_1_6 0 s1 x9_im_a6 0 -857550102.4241862
Gr10_1_6 0 s1 x10_a6 0 7527111261.867932
Gr11_re_1_6 0 s1 x11_re_a6 0 -755585307.6352278
Gr11_im_1_6 0 s1 x11_im_a6 0 -276375125.31455207
Gr12_re_1_6 0 s1 x12_re_a6 0 -109310979.17598344
Gr12_im_1_6 0 s1 x12_im_a6 0 -120463038.02762637
Gd1_7 0 s1 p7 0 -6.817449292422819e-08
Fd1_7 0 s1 V7 -3.4087246462114096e-06
Gr1_1_7 0 s1 x1_a7 0 439002358279.52716
Gr2_re_1_7 0 s1 x2_re_a7 0 33706328335.56831
Gr2_im_1_7 0 s1 x2_im_a7 0 -72025653991.08278
Gr3_re_1_7 0 s1 x3_re_a7 0 52600271271.21384
Gr3_im_1_7 0 s1 x3_im_a7 0 110791364483.4102
Gr4_re_1_7 0 s1 x4_re_a7 0 -4083404121.4479423
Gr4_im_1_7 0 s1 x4_im_a7 0 -238332091681.61203
Gr5_re_1_7 0 s1 x5_re_a7 0 -14166578149.105232
Gr5_im_1_7 0 s1 x5_im_a7 0 14580804801.089325
Gr6_re_1_7 0 s1 x6_re_a7 0 152677351.88336352
Gr6_im_1_7 0 s1 x6_im_a7 0 360978072.32578766
Gr7_re_1_7 0 s1 x7_re_a7 0 852987401089.0199
Gr7_im_1_7 0 s1 x7_im_a7 0 27918467976.441093
Gr8_1_7 0 s1 x8_a7 0 -1870319318857.6208
Gr9_re_1_7 0 s1 x9_re_a7 0 -104089461288.10593
Gr9_im_1_7 0 s1 x9_im_a7 0 -456378172120.3148
Gr10_1_7 0 s1 x10_a7 0 14577711727.47031
Gr11_re_1_7 0 s1 x11_re_a7 0 -1022470605.9443845
Gr11_im_1_7 0 s1 x11_im_a7 0 -197536909.3053731
Gr12_re_1_7 0 s1 x12_re_a7 0 -125536528.28697081
Gr12_im_1_7 0 s1 x12_im_a7 0 -134137571.39012009
Gd1_8 0 s1 p8 0 -3.0196381731590476e-07
Fd1_8 0 s1 V8 -1.5098190865795239e-05
Gr1_1_8 0 s1 x1_a8 0 434242624746.4456
Gr2_re_1_8 0 s1 x2_re_a8 0 34462886239.39306
Gr2_im_1_8 0 s1 x2_im_a8 0 -70844954620.47858
Gr3_re_1_8 0 s1 x3_re_a8 0 54404091186.43525
Gr3_im_1_8 0 s1 x3_im_a8 0 111398350069.14487
Gr4_re_1_8 0 s1 x4_re_a8 0 -4290772832.2414393
Gr4_im_1_8 0 s1 x4_im_a8 0 -240616421259.61453
Gr5_re_1_8 0 s1 x5_re_a8 0 -14025592591.127745
Gr5_im_1_8 0 s1 x5_im_a8 0 14607932753.897585
Gr6_re_1_8 0 s1 x6_re_a8 0 153107346.58557814
Gr6_im_1_8 0 s1 x6_im_a8 0 364268015.3891033
Gr7_re_1_8 0 s1 x7_re_a8 0 858905789200.329
Gr7_im_1_8 0 s1 x7_im_a8 0 28232399641.941826
Gr8_1_8 0 s1 x8_a8 0 -1882297474370.8362
Gr9_re_1_8 0 s1 x9_re_a8 0 -105016036278.92697
Gr9_im_1_8 0 s1 x9_im_a8 0 -459650077559.73334
Gr10_1_8 0 s1 x10_a8 0 14663835173.143059
Gr11_re_1_8 0 s1 x11_re_a8 0 -1027408491.0417877
Gr11_im_1_8 0 s1 x11_im_a8 0 -198948508.88034016
Gr12_re_1_8 0 s1 x12_re_a8 0 -126635247.87315646
Gr12_im_1_8 0 s1 x12_im_a8 0 -135545428.9780923
*
* State networks driven by port 1
Cx1_a1 x1_a1 0 1.0
Gx1_a1 0 x1_a1 p1 0 0.07071067811865475
Fx1_a1 0 x1_a1 V1 3.5355339059327378
Rp1_a1 0 x1_a1 9.217407145044509e-14
Cx2_re_a1 x2_re_a1 0 1.0
Gx2_re_a1 0 x2_re_a1 p1 0 0.1414213562373095
Fx2_re_a1 0 x2_re_a1 V1 7.0710678118654755
Rp2_re_re_a1 0 x2_re_a1 1.0786132166118383e-12
Gp2_re_im_a1 0 x2_re_a1 x2_im_a1 0 5111233610923.186
Cx2_im_a1 x2_im_a1 0 1.0
Gp2_im_re_a1 0 x2_im_a1 x2_re_a1 0 -5111233610923.186
Rp2_im_im_a1 0 x2_im_a1 1.0786132166118383e-12
Cx3_re_a1 x3_re_a1 0 1.0
Gx3_re_a1 0 x3_re_a1 p1 0 0.1414213562373095
Fx3_re_a1 0 x3_re_a1 V1 7.0710678118654755
Rp3_re_re_a1 0 x3_re_a1 9.88767760173926e-13
Gp3_re_im_a1 0 x3_re_a1 x3_im_a1 0 3508473312410.142
Cx3_im_a1 x3_im_a1 0 1.0
Gp3_im_re_a1 0 x3_im_a1 x3_re_a1 0 -3508473312410.142
Rp3_im_im_a1 0 x3_im_a1 9.88767760173926e-13
Cx4_re_a1 x4_re_a1 0 1.0
Gx4_re_a1 0 x4_re_a1 p1 0 0.1414213562373095
Fx4_re_a1 0 x4_re_a1 V1 7.0710678118654755
Rp4_re_re_a1 0 x4_re_a1 8.533325723003939e-13
Gp4_re_im_a1 0 x4_re_a1 x4_im_a1 0 2766197540793.715
Cx4_im_a1 x4_im_a1 0 1.0
Gp4_im_re_a1 0 x4_im_a1 x4_re_a1 0 -2766197540793.715
Rp4_im_im_a1 0 x4_im_a1 8.533325723003939e-13
Cx5_re_a1 x5_re_a1 0 1.0
Gx5_re_a1 0 x5_re_a1 p1 0 0.1414213562373095
Fx5_re_a1 0 x5_re_a1 V1 7.0710678118654755
Rp5_re_re_a1 0 x5_re_a1 2.410991705178112e-12
Gp5_re_im_a1 0 x5_re_a1 x5_im_a1 0 2874456996728.0483
Cx5_im_a1 x5_im_a1 0 1.0
Gp5_im_re_a1 0 x5_im_a1 x5_re_a1 0 -2874456996728.0483
Rp5_im_im_a1 0 x5_im_a1 2.410991705178112e-12
Cx6_re_a1 x6_re_a1 0 1.0
Gx6_re_a1 0 x6_re_a1 p1 0 0.1414213562373095
Fx6_re_a1 0 x6_re_a1 V1 7.0710678118654755
Rp6_re_re_a1 0 x6_re_a1 1.6191077353663697e-11
Gp6_re_im_a1 0 x6_re_a1 x6_im_a1 0 2387826528783.5156
Cx6_im_a1 x6_im_a1 0 1.0
Gp6_im_re_a1 0 x6_im_a1 x6_re_a1 0 -2387826528783.5156
Rp6_im_im_a1 0 x6_im_a1 1.6191077353663697e-11
Cx7_re_a1 x7_re_a1 0 1.0
Gx7_re_a1 0 x7_re_a1 p1 0 0.1414213562373095
Fx7_re_a1 0 x7_re_a1 V1 7.0710678118654755
Rp7_re_re_a1 0 x7_re_a1 1.1670965837274465e-12
Gp7_re_im_a1 0 x7_re_a1 x7_im_a1 0 590648106330.5088
Cx7_im_a1 x7_im_a1 0 1.0
Gp7_im_re_a1 0 x7_im_a1 x7_re_a1 0 -590648106330.5088
Rp7_im_im_a1 0 x7_im_a1 1.1670965837274465e-12
Cx8_a1 x8_a1 0 1.0
Gx8_a1 0 x8_a1 p1 0 0.07071067811865475
Fx8_a1 0 x8_a1 V1 3.5355339059327378
Rp8_a1 0 x8_a1 1.057099515142882e-12
Cx9_re_a1 x9_re_a1 0 1.0
Gx9_re_a1 0 x9_re_a1 p1 0 0.1414213562373095
Fx9_re_a1 0 x9_re_a1 V1 7.0710678118654755
Rp9_re_re_a1 0 x9_re_a1 1.5534303609826191e-12
Gp9_re_im_a1 0 x9_re_a1 x9_im_a1 0 455649394468.80255
Cx9_im_a1 x9_im_a1 0 1.0
Gp9_im_re_a1 0 x9_im_a1 x9_re_a1 0 -455649394468.80255
Rp9_im_im_a1 0 x9_im_a1 1.5534303609826191e-12
Cx10_a1 x10_a1 0 1.0
Gx10_a1 0 x10_a1 p1 0 0.07071067811865475
Fx10_a1 0 x10_a1 V1 3.5355339059327378
Rp10_a1 0 x10_a1 5.21381713713202e-12
Cx11_re_a1 x11_re_a1 0 1.0
Gx11_re_a1 0 x11_re_a1 p1 0 0.1414213562373095
Fx11_re_a1 0 x11_re_a1 V1 7.0710678118654755
Rp11_re_re_a1 0 x11_re_a1 1.673721870740383e-11
Gp11_re_im_a1 0 x11_re_a1 x11_im_a1 0 51505589949.64772
Cx11_im_a1 x11_im_a1 0 1.0
Gp11_im_re_a1 0 x11_im_a1 x11_re_a1 0 -51505589949.64772
Rp11_im_im_a1 0 x11_im_a1 1.673721870740383e-11
Cx12_re_a1 x12_re_a1 0 1.0
Gx12_re_a1 0 x12_re_a1 p1 0 0.1414213562373095
Fx12_re_a1 0 x12_re_a1 V1 7.0710678118654755
Rp12_re_re_a1 0 x12_re_a1 6.344273526229328e-11
Gp12_re_im_a1 0 x12_re_a1 x12_im_a1 0 6300408112.88573
Cx12_im_a1 x12_im_a1 0 1.0
Gp12_im_re_a1 0 x12_im_a1 x12_re_a1 0 -6300408112.88573
Rp12_im_im_a1 0 x12_im_a1 6.344273526229328e-11
*
* Port network for port 2
V2 p2 s2 0
R2 s2 0 50.0
Gd2_1 0 s2 p1 0 1.106369085535075e-07
Fd2_1 0 s2 V1 5.531845427675376e-06
Gr1_2_1 0 s2 x1_a1 0 711127004629.6653
Gr2_re_2_1 0 s2 x2_re_a1 0 26762972959.90637
Gr2_im_2_1 0 s2 x2_im_a1 0 -34689915558.41925
Gr3_re_2_1 0 s2 x3_re_a1 0 181497839590.13922
Gr3_im_2_1 0 s2 x3_im_a1 0 21586561566.99728
Gr4_re_2_1 0 s2 x4_re_a1 0 -33718822461.981613
Gr4_im_2_1 0 s2 x4_im_a1 0 -190309085158.92166
Gr5_re_2_1 0 s2 x5_re_a1 0 -12808940807.053106
Gr5_im_2_1 0 s2 x5_im_a1 0 19007187371.19272
Gr6_re_2_1 0 s2 x6_re_a1 0 161390837.15409532
Gr6_im_2_1 0 s2 x6_im_a1 0 263347412.9071982
Gr7_re_2_1 0 s2 x7_re_a1 0 703743620703.0912
Gr7_im_2_1 0 s2 x7_im_a1 0 14449133451.02174
Gr8_2_1 0 s2 x8_a1 0 -1682721393490.9937
Gr9_re_2_1 0 s2 x9_re_a1 0 -70816762791.7658
Gr9_im_2_1 0 s2 x9_im_a1 0 -500088627117.30176
Gr10_2_1 0 s2 x10_a1 0 12235714994.474215
Gr11_re_2_1 0 s2 x11_re_a1 0 -838915443.720103
Gr11_im_2_1 0 s2 x11_im_a1 0 -153957299.96264732
Gr12_re_2_1 0 s2 x12_re_a1 0 -102267373.365791
Gr12_im_2_1 0 s2 x12_im_a1 0 -121496435.226885
Gd2_2 0 s2 p2 0 1.4745487133205335e-07
Fd2_2 0 s2 V2 7.372743566602669e-06
Gr1_2_2 0 s2 x1_a2 0 -2846756606023.3433
Gr2_re_2_2 0 s2 x2_re_a2 0 138717887007.94144
Gr2_im_2_2 0 s2 x2_im_a2 0 -16993627182.968668
Gr3_re_2_2 0 s2 x3_re_a2 0 168843218198.71573
Gr3_im_2_2 0 s2 x3_im_a2 0 -2147163755.9130619
Gr4_re_2_2 0 s2 x4_re_a2 0 28319976541.929577
Gr4_im_2_2 0 s2 x4_im_a2 0 -225114245616.00433
Gr5_re_2_2 0 s2 x5_re_a2 0 -8838751672.119574
Gr5_im_2_2 0 s2 x5_im_a2 0 33035252482.91496
Gr6_re_2_2 0 s2 x6_re_a2 0 30801931.71965637
Gr6_im_2_2 0 s2 x6_im_a2 0 389086706.82200634
Gr7_re_2_2 0 s2 x7_re_a2 0 820979539097.4203
Gr7_im_2_2 0 s2 x7_im_a2 0 179889273732.26996
Gr8_2_2 0 s2 x8_a2 0 -1960711794335.1318
Gr9_re_2_2 0 s2 x9_re_a2 0 70604282310.87479
Gr9_im_2_2 0 s2 x9_im_a2 0 -495972269770.7758
Gr10_2_2 0 s2 x10_a2 0 18771471206.64559
Gr11_re_2_2 0 s2 x11_re_a2 0 -1551891666.023899
Gr11_im_2_2 0 s2 x11_im_a2 0 -327540066.4222899
Gr12_re_2_2 0 s2 x12_re_a2 0 -198156228.02301583
Gr12_im_2_2 0 s2 x12_im_a2 0 -205619289.475435
Gd2_3 0 s2 p3 0 1.2944673880399549e-06
Fd2_3 0 s2 V3 6.472336940199774e-05
Gr1_2_3 0 s2 x1_a3 0 94426753169.52975
Gr2_re_2_3 0 s2 x2_re_a3 0 15601556905.292225
Gr2_im_2_3 0 s2 x2_im_a3 0 -21832769242.844383
Gr3_re_2_3 0 s2 x3_re_a3 0 -101029139437.7002
Gr3_im_2_3 0 s2 x3_im_a3 0 -19324634860.316456
Gr4_re_2_3 0 s2 x4_re_a3 0 -47757559923.60549
Gr4_im_2_3 0 s2 x4_im_a3 0 100012628149.02605
Gr5_re_2_3 0 s2 x5_re_a3 0 -25980044012.22198
Gr5_im_2_3 0 s2 x5_im_a3 0 10070286309.166695
Gr6_re_2_3 0 s2 x6_re_a3 0 16563660.361400316
Gr6_im_2_3 0 s2 x6_im_a3 0 -230545084.75103614
Gr7_re_2_3 0 s2 x7_re_a3 0 -453618940620.06354
Gr7_im_2_3 0 s2 x7_im_a3 0 -80007534239.19833
Gr8_2_3 0 s2 x8_a3 0 1038301705434.528
Gr9_re_2_3 0 s2 x9_re_a3 0 64259644619.98196
Gr9_im_2_3 0 s2 x9_im_a3 0 244720292719.8523
Gr10_2_3 0 s2 x10_a3 0 -9607030089.620949
Gr11_re_2_3 0 s2 x11_re_a3 0 722449671.2154067
Gr11_im_2_3 0 s2 x11_im_a3 0 119220867.29241315
Gr12_re_2_3 0 s2 x12_re_a3 0 88001670.53129117
Gr12_im_2_3 0 s2 x12_im_a3 0 94003339.5922344
Gd2_4 0 s2 p4 0 1.3313692013650069e-06
Fd2_4 0 s2 V4 6.656846006825035e-05
Gr1_2_4 0 s2 x1_a4 0 99851976858.41858
Gr2_re_2_4 0 s2 x2_re_a4 0 15488938034.716108
Gr2_im_2_4 0 s2 x2_im_a4 0 -22219753034.05911
Gr3_re_2_4 0 s2 x3_re_a4 0 -100891523606.04173
Gr3_im_2_4 0 s2 x3_im_a4 0 -19785668092.11049
Gr4_re_2_4 0 s2 x4_re_a4 0 -48651982073.165565
Gr4_im_2_4 0 s2 x4_im_a4 0 100022718832.38977
Gr5_re_2_4 0 s2 x5_re_a4 0 -25943701934.977844
Gr5_im_2_4 0 s2 x5_im_a4 0 10018848942.611063
Gr6_re_2_4 0 s2 x6_re_a4 0 17941418.949468374
Gr6_im_2_4 0 s2 x6_im_a4 0 -230671177.7683033
Gr7_re_2_4 0 s2 x7_re_a4 0 -451434003536.97516
Gr7_im_2_4 0 s2 x7_im_a4 0 -80628906600.06918
Gr8_2_4 0 s2 x8_a4 0 1033487375392.6152
Gr9_re_2_4 0 s2 x9_re_a4 0 63646939265.3033
Gr9_im_2_4 0 s2 x9_im_a4 0 243704056195.45853
Gr10_2_4 0 s2 x10_a4 0 -9598745179.426594
Gr11_re_2_4 0 s2 x11_re_a4 0 723228868.9846551
Gr11_im_2_4 0 s2 x11_im_a4 0 121275118.86100394
Gr12_re_2_4 0 s2 x12_re_a4 0 88439956.54561263
Gr12_im_2_4 0 s2 x12_im_a4 0 94434139.50941747
Gd2_5 0 s2 p5 0 2.5426758811140924e-07
Fd2_5 0 s2 V5 1.2713379405570463e-05
Gr1_2_5 0 s2 x1_a5 0 -195496636695.23114
Gr2_re_2_5 0 s2 x2_re_a5 0 -52680366778.617546
Gr2_im_2_5 0 s2 x2_im_a5 0 -19881308837.588043
Gr3_re_2_5 0 s2 x3_re_a5 0 20408589466.759113
Gr3_im_2_5 0 s2 x3_im_a5 0 13123512572.940224
Gr4_re_2_5 0 s2 x4_re_a5 0 49865132032.87705
Gr4_im_2_5 0 s2 x4_im_a5 0 70173533080.50174
Gr5_re_2_5 0 s2 x5_re_a5 0 -28499366446.866535
Gr5_im_2_5 0 s2 x5_im_a5 0 17318873392.46127
Gr6_re_2_5 0 s2 x6_re_a5 0 -101555379.69420578
Gr6_im_2_5 0 s2 x6_im_a5 0 -46699534.81633367
Gr7_re_2_5 0 s2 x7_re_a5 0 -212689221893.14108
Gr7_im_2_5 0 s2 x7_im_a5 0 31823109826.068863
Gr8_2_5 0 s2 x8_a5 0 653355114775.0771
Gr9_re_2_5 0 s2 x9_re_a5 0 -68532436742.08371
Gr9_im_2_5 0 s2 x9_im_a5 0 78599233663.9376
Gr10_2_5 0 s2 x10_a5 0 -1255328601.2999265
Gr11_re_2_5 0 s2 x11_re_a5 0 104848303.66450208
Gr11_im_2_5 0 s2 x11_im_a5 0 -24677456.174572073
Gr12_re_2_5 0 s2 x12_re_a5 0 16034970.469042145
Gr12_im_2_5 0 s2 x12_im_a5 0 32944924.22557093
Gd2_6 0 s2 p6 0 3.9229265990332187e-07
Fd2_6 0 s2 V6 1.9614632995166095e-05
Gr1_2_6 0 s2 x1_a6 0 335893581472.7926
Gr2_re_2_6 0 s2 x2_re_a6 0 9763584053.906757
Gr2_im_2_6 0 s2 x2_im_a6 0 14489995538.663887
Gr3_re_2_6 0 s2 x3_re_a6 0 53506128732.045395
Gr3_im_2_6 0 s2 x3_im_a6 0 -109399011350.69809
Gr4_re_2_6 0 s2 x4_re_a6 0 -71810131963.54855
Gr4_im_2_6 0 s2 x4_im_a6 0 122134010430.3116
Gr5_re_2_6 0 s2 x5_re_a6 0 -29206476699.235332
Gr5_im_2_6 0 s2 x5_im_a6 0 1268666358.778243
Gr6_re_2_6 0 s2 x6_re_a6 0 22085054.332509775
Gr6_im_2_6 0 s2 x6_im_a6 0 -282540045.296372
Gr7_re_2_6 0 s2 x7_re_a6 0 -545152525094.2057
Gr7_im_2_6 0 s2 x7_im_a6 0 -90022677117.40752
Gr8_2_6 0 s2 x8_a6 0 1329538303851.4712
Gr9_re_2_6 0 s2 x9_re_a6 0 20605719824.76004
Gr9_im_2_6 0 s2 x9_im_a6 0 435279541560.2454
Gr10_2_6 0 s2 x10_a6 0 -11284032396.77168
Gr11_re_2_6 0 s2 x11_re_a6 0 777365703.347415
Gr11_im_2_6 0 s2 x11_im_a6 0 125335570.10624033
Gr12_re_2_6 0 s2 x12_re_a6 0 85356349.7071374
Gr12_im_2_6 0 s2 x12_im_a6 0 84988279.61911857
Gd2_7 0 s2 p7 0 -2.9154646683304116e-07
Fd2_7 0 s2 V7 -1.4577323341652057e-05
Gr1_2_7 0 s2 x1_a7 0 1715651719756.7576
Gr2_re_2_7 0 s2 x2_re_a7 0 -10319954530.64253
Gr2_im_2_7 0 s2 x2_im_a7 0 -25611843138.38118
Gr3_re_2_7 0 s2 x3_re_a7 0 29970805345.15803
Gr3_im_2_7 0 s2 x3_im_a7 0 63340540595.762344
Gr4_re_2_7 0 s2 x4_re_a7 0 -14067925052.354355
Gr4_im_2_7 0 s2 x4_im_a7 0 -212751216183.98657
Gr5_re_2_7 0 s2 x5_re_a7 0 -11207265758.055225
Gr5_im_2_7 0 s2 x5_im_a7 0 21997767797.223328
Gr6_re_2_7 0 s2 x6_re_a7 0 131358907.42749143
Gr6_im_2_7 0 s2 x6_im_a7 0 304697396.6860747
Gr7_re_2_7 0 s2 x7_re_a7 0 761431669304.0537
Gr7_im_2_7 0 s2 x7_im_a7 0 59568122202.338974
Gr8_2_7 0 s2 x8_a7 0 -1709849940827.1843
Gr9_re_2_7 0 s2 x9_re_a7 0 -113090913103.93973
Gr9_im_2_7 0 s2 x9_im_a7 0 -411080076363.46954
Gr10_2_7 0 s2 x10_a7 0 15260759475.257423
Gr11_re_2_7 0 s2 x11_re_a7 0 -1145516434.244423
Gr11_im_2_7 0 s2 x11_im_a7 0 -230858599.31036788
Gr12_re_2_7 0 s2 x12_re_a7 0 -142755848.22031182
Gr12_im_2_7 0 s2 x12_im_a7 0 -155808266.37233302
Gd2_8 0 s2 p8 0 1.0254172583176387e-07
Fd2_8 0 s2 V8 5.127086291588194e-06
Gr1_2_8 0 s2 x1_a8 0 1713614174954.063
Gr2_re_2_8 0 s2 x2_re_a8 0 -9646211559.362097
Gr2_im_2_8 0 s2 x2_im_a8 0 -25399818998.611656
Gr3_re_2_8 0 s2 x3_re_a8 0 30419089453.06304
Gr3_im_2_8 0 s2 x3_im_a8 0 62182640576.38591
Gr4_re_2_8 0 s2 x4_re_a8 0 -15315926514.624645
Gr4_im_2_8 0 s2 x4_im_a8 0 -211858253335.57135
Gr5_re_2_8 0 s2 x5_re_a8 0 -11225433900.648241
Gr5_im_2_8 0 s2 x5_im_a8 0 21834907630.51079
Gr6_re_2_8 0 s2 x6_re_a8 0 132482066.56789172
Gr6_im_2_8 0 s2 x6_im_a8 0 301843677.0630513
Gr7_re_2_8 0 s2 x7_re_a8 0 755181098642.1791
Gr7_im_2_8 0 s2 x7_im_a8 0 57843397950.06571
Gr8_2_8 0 s2 x8_a8 0 -1695982115934.2559
Gr9_re_2_8 0 s2 x9_re_a8 0 -112936487313.55722
Gr9_im_2_8 0 s2 x9_im_a8 0 -406930401614.52313
Gr10_2_8 0 s2 x10_a8 0 15080864196.232027
Gr11_re_2_8 0 s2 x11_re_a8 0 -1130874058.7618985
Gr11_im_2_8 0 s2 x11_im_a8 0 -227136927.13356128
Gr12_re_2_8 0 s2 x12_re_a8 0 -140772314.28787634
Gr12_im_2_8 0 s2 x12_im_a8 0 -153650330.3315707
*
* State networks driven by port 2
Cx1_a2 x1_a2 0 1.0
Gx1_a2 0 x1_a2 p2 0 0.07071067811865475
Fx1_a2 0 x1_a2 V2 3.5355339059327378
Rp1_a2 0 x1_a2 9.217407145044509e-14
Cx2_re_a2 x2_re_a2 0 1.0
Gx2_re_a2 0 x2_re_a2 p2 0 0.1414213562373095
Fx2_re_a2 0 x2_re_a2 V2 7.0710678118654755
Rp2_re_re_a2 0 x2_re_a2 1.0786132166118383e-12
Gp2_re_im_a2 0 x2_re_a2 x2_im_a2 0 5111233610923.186
Cx2_im_a2 x2_im_a2 0 1.0
Gp2_im_re_a2 0 x2_im_a2 x2_re_a2 0 -5111233610923.186
Rp2_im_im_a2 0 x2_im_a2 1.0786132166118383e-12
Cx3_re_a2 x3_re_a2 0 1.0
Gx3_re_a2 0 x3_re_a2 p2 0 0.1414213562373095
Fx3_re_a2 0 x3_re_a2 V2 7.0710678118654755
Rp3_re_re_a2 0 x3_re_a2 9.88767760173926e-13
Gp3_re_im_a2 0 x3_re_a2 x3_im_a2 0 3508473312410.142
Cx3_im_a2 x3_im_a2 0 1.0
Gp3_im_re_a2 0 x3_im_a2 x3_re_a2 0 -3508473312410.142
Rp3_im_im_a2 0 x3_im_a2 9.88767760173926e-13
Cx4_re_a2 x4_re_a2 0 1.0
Gx4_re_a2 0 x4_re_a2 p2 0 0.1414213562373095
Fx4_re_a2 0 x4_re_a2 V2 7.0710678118654755
Rp4_re_re_a2 0 x4_re_a2 8.533325723003939e-13
Gp4_re_im_a2 0 x4_re_a2 x4_im_a2 0 2766197540793.715
Cx4_im_a2 x4_im_a2 0 1.0
Gp4_im_re_a2 0 x4_im_a2 x4_re_a2 0 -2766197540793.715
Rp4_im_im_a2 0 x4_im_a2 8.533325723003939e-13
Cx5_re_a2 x5_re_a2 0 1.0
Gx5_re_a2 0 x5_re_a2 p2 0 0.1414213562373095
Fx5_re_a2 0 x5_re_a2 V2 7.0710678118654755
Rp5_re_re_a2 0 x5_re_a2 2.410991705178112e-12
Gp5_re_im_a2 0 x5_re_a2 x5_im_a2 0 2874456996728.0483
Cx5_im_a2 x5_im_a2 0 1.0
Gp5_im_re_a2 0 x5_im_a2 x5_re_a2 0 -2874456996728.0483
Rp5_im_im_a2 0 x5_im_a2 2.410991705178112e-12
Cx6_re_a2 x6_re_a2 0 1.0
Gx6_re_a2 0 x6_re_a2 p2 0 0.1414213562373095
Fx6_re_a2 0 x6_re_a2 V2 7.0710678118654755
Rp6_re_re_a2 0 x6_re_a2 1.6191077353663697e-11
Gp6_re_im_a2 0 x6_re_a2 x6_im_a2 0 2387826528783.5156
Cx6_im_a2 x6_im_a2 0 1.0
Gp6_im_re_a2 0 x6_im_a2 x6_re_a2 0 -2387826528783.5156
Rp6_im_im_a2 0 x6_im_a2 1.6191077353663697e-11
Cx7_re_a2 x7_re_a2 0 1.0
Gx7_re_a2 0 x7_re_a2 p2 0 0.1414213562373095
Fx7_re_a2 0 x7_re_a2 V2 7.0710678118654755
Rp7_re_re_a2 0 x7_re_a2 1.1670965837274465e-12
Gp7_re_im_a2 0 x7_re_a2 x7_im_a2 0 590648106330.5088
Cx7_im_a2 x7_im_a2 0 1.0
Gp7_im_re_a2 0 x7_im_a2 x7_re_a2 0 -590648106330.5088
Rp7_im_im_a2 0 x7_im_a2 1.1670965837274465e-12
Cx8_a2 x8_a2 0 1.0
Gx8_a2 0 x8_a2 p2 0 0.07071067811865475
Fx8_a2 0 x8_a2 V2 3.5355339059327378
Rp8_a2 0 x8_a2 1.057099515142882e-12
Cx9_re_a2 x9_re_a2 0 1.0
Gx9_re_a2 0 x9_re_a2 p2 0 0.1414213562373095
Fx9_re_a2 0 x9_re_a2 V2 7.0710678118654755
Rp9_re_re_a2 0 x9_re_a2 1.5534303609826191e-12
Gp9_re_im_a2 0 x9_re_a2 x9_im_a2 0 455649394468.80255
Cx9_im_a2 x9_im_a2 0 1.0
Gp9_im_re_a2 0 x9_im_a2 x9_re_a2 0 -455649394468.80255
Rp9_im_im_a2 0 x9_im_a2 1.5534303609826191e-12
Cx10_a2 x10_a2 0 1.0
Gx10_a2 0 x10_a2 p2 0 0.07071067811865475
Fx10_a2 0 x10_a2 V2 3.5355339059327378
Rp10_a2 0 x10_a2 5.21381713713202e-12
Cx11_re_a2 x11_re_a2 0 1.0
Gx11_re_a2 0 x11_re_a2 p2 0 0.1414213562373095
Fx11_re_a2 0 x11_re_a2 V2 7.0710678118654755
Rp11_re_re_a2 0 x11_re_a2 1.673721870740383e-11
Gp11_re_im_a2 0 x11_re_a2 x11_im_a2 0 51505589949.64772
Cx11_im_a2 x11_im_a2 0 1.0
Gp11_im_re_a2 0 x11_im_a2 x11_re_a2 0 -51505589949.64772
Rp11_im_im_a2 0 x11_im_a2 1.673721870740383e-11
Cx12_re_a2 x12_re_a2 0 1.0
Gx12_re_a2 0 x12_re_a2 p2 0 0.1414213562373095
Fx12_re_a2 0 x12_re_a2 V2 7.0710678118654755
Rp12_re_re_a2 0 x12_re_a2 6.344273526229328e-11
Gp12_re_im_a2 0 x12_re_a2 x12_im_a2 0 6300408112.88573
Cx12_im_a2 x12_im_a2 0 1.0
Gp12_im_re_a2 0 x12_im_a2 x12_re_a2 0 -6300408112.88573
Rp12_im_im_a2 0 x12_im_a2 6.344273526229328e-11
*
* Port network for port 3
V3 p3 s3 0
R3 s3 0 50.0
Gd3_1 0 s3 p1 0 1.1070275995694878e-06
Fd3_1 0 s3 V1 5.535137997847439e-05
Gr1_3_1 0 s3 x1_a1 0 857361566080.1488
Gr2_re_3_1 0 s3 x2_re_a1 0 8684947993.166468
Gr2_im_3_1 0 s3 x2_im_a1 0 -15923940731.021841
Gr3_re_3_1 0 s3 x3_re_a1 0 -103916626605.43747
Gr3_im_3_1 0 s3 x3_im_a1 0 -45163661724.150635
Gr4_re_3_1 0 s3 x4_re_a1 0 -30262033967.711536
Gr4_im_3_1 0 s3 x4_im_a1 0 62998036421.64438
Gr5_re_3_1 0 s3 x5_re_a1 0 -33350891465.43051
Gr5_im_3_1 0 s3 x5_im_a1 0 5348976766.903288
Gr6_re_3_1 0 s3 x6_re_a1 0 -41164696.83329941
Gr6_im_3_1 0 s3 x6_im_a1 0 -153219196.53297424
Gr7_re_3_1 0 s3 x7_re_a1 0 -257008931606.6618
Gr7_im_3_1 0 s3 x7_im_a1 0 42973443156.12788
Gr8_3_1 0 s3 x8_a1 0 568368846274.0616
Gr9_re_3_1 0 s3 x9_re_a1 0 45078140106.72675
Gr9_im_3_1 0 s3 x9_im_a1 0 94088277840.46284
Gr10_3_1 0 s3 x10_a1 0 -110888909.69124112
Gr11_re_3_1 0 s3 x11_re_a1 0 -143417952.32582083
Gr11_im_3_1 0 s3 x11_im_a1 0 -128587123.87226635
Gr12_re_3_1 0 s3 x12_re_a1 0 -30890711.399152145
Gr12_im_3_1 0 s3 x12_im_a1 0 -38717187.547019124
Gd3_2 0 s3 p2 0 1.2944673880399549e-06
Fd3_2 0 s3 V2 6.472336940199774e-05
Gr1_3_2 0 s3 x1_a2 0 94426753169.49622
Gr2_re_3_2 0 s3 x2_re_a2 0 15601556905.293236
Gr2_im_3_2 0 s3 x2_im_a2 0 -21832769242.842354
Gr3_re_3_2 0 s3 x3_re_a2 0 -101029139437.69975
Gr3_im_3_2 0 s3 x3_im_a2 0 -19324634860.31664
Gr4_re_3_2 0 s3 x4_re_a2 0 -47757559923.606224
Gr4_im_3_2 0 s3 x4_im_a2 0 100012628149.02968
Gr5_re_3_2 0 s3 x5_re_a2 0 -25980044012.22194
Gr5_im_3_2 0 s3 x5_im_a2 0 10070286309.166414
Gr6_re_3_2 0 s3 x6_re_a2 0 16563660.361404052
Gr6_im_3_2 0 s3 x6_im_a2 0 -230545084.7510417
Gr7_re_3_2 0 s3 x7_re_a2 0 -453618940620.13275
Gr7_im_3_2 0 s3 x7_im_a2 0 -80007534239.2157
Gr8_3_2 0 s3 x8_a2 0 1038301705434.6818
Gr9_re_3_2 0 s3 x9_re_a2 0 64259644619.98499
Gr9_im_3_2 0 s3 x9_im_a2 0 244720292719.8985
Gr10_3_2 0 s3 x10_a2 0 -9607030089.62268
Gr11_re_3_2 0 s3 x11_re_a2 0 722449671.2155459
Gr11_im_3_2 0 s3 x11_im_a2 0 119220867.29245703
Gr12_re_3_2 0 s3 x12_re_a2 0 88001670.53130819
Gr12_im_3_2 0 s3 x12_im_a2 0 94003339.59226492
Gd3_3 0 s3 p3 0 -1.138174460730834e-06
Fd3_3 0 s3 V3 -5.690872303654171e-05
Gr1_3_3 0 s3 x1_a3 0 -4323821522397.3965
Gr2_re_3_3 0 s3 x2_re_a3 0 299333246605.73376
Gr2_im_3_3 0 s3 x2_im_a3 0 -2920100841.6949563
Gr3_re_3_3 0 s3 x3_re_a3 0 -210716221798.53348
Gr3_im_3_3 0 s3 x3_im_a3 0 -111311250631.89893
Gr4_re_3_3 0 s3 x4_re_a3 0 395012093030.64343
Gr4_im_3_3 0 s3 x4_im_a3 0 271337257094.031
Gr5_re_3_3 0 s3 x5_re_a3 0 -53292451227.11749
Gr5_im_3_3 0 s3 x5_im_a3 0 18788286266.066082
Gr6_re_3_3 0 s3 x6_re_a3 0 -2590023637.217105
Gr6_im_3_3 0 s3 x6_im_a3 0 -512058933.9145171
Gr7_re_3_3 0 s3 x7_re_a3 0 -1104884553577.627
Gr7_im_3_3 0 s3 x7_im_a3 0 324504987859.9736
Gr8_3_3 0 s3 x8_a3 0 2703617519824.5034
Gr9_re_3_3 0 s3 x9_re_a3 0 267583508510.9704
Gr9_im_3_3 0 s3 x9_im_a3 0 649227796048.0626
Gr10_3_3 0 s3 x10_a3 0 -17707822610.69953
Gr11_re_3_3 0 s3 x11_re_a3 0 1096771289.3172812
Gr11_im_3_3 0 s3 x11_im_a3 0 149124638.70683807
Gr12_re_3_3 0 s3 x12_re_a3 0 116451499.072578
Gr12_im_3_3 0 s3 x12_im_a3 0 128417546.13460235
Gd3_4 0 s3 p4 0 1.3056178841308608e-06
Fd3_4 0 s3 V4 6.528089420654304e-05
Gr1_3_4 0 s3 x1_a4 0 2416742876261.6606
Gr2_re_3_4 0 s3 x2_re_a4 0 -118241995048.32257
Gr2_im_3_4 0 s3 x2_im_a4 0 -15550466514.0627
Gr3_re_3_4 0 s3 x3_re_a4 0 595058158262.7478
Gr3_im_3_4 0 s3 x3_im_a4 0 121007732555.02357
Gr4_re_3_4 0 s3 x4_re_a4 0 -367793658596.4223
Gr4_im_3_4 0 s3 x4_im_a4 0 -804745004397.8765
Gr5_re_3_4 0 s3 x5_re_a4 0 31617746491.067028
Gr5_im_3_4 0 s3 x5_im_a4 0 40397042204.44116
Gr6_re_3_4 0 s3 x6_re_a4 0 2781111087.0831475
Gr6_im_3_4 0 s3 x6_im_a4 0 1401733657.2070506
Gr7_re_3_4 0 s3 x7_re_a4 0 3020850164633.167
Gr7_im_3_4 0 s3 x7_im_a4 0 -78976593325.64807
Gr8_3_4 0 s3 x8_a4 0 -6791170089600.762
Gr9_re_3_4 0 s3 x9_re_a4 0 -493888459716.0413
Gr9_im_3_4 0 s3 x9_im_a4 0 -1814779829811.233
Gr10_3_4 0 s3 x10_a4 0 55664992258.82559
Gr11_re_3_4 0 s3 x11_re_a4 0 -3895516982.8365498
Gr11_im_3_4 0 s3 x11_im_a4 0 -703526088.7179638
Gr12_re_3_4 0 s3 x12_re_a4 0 -466017119.862516
Gr12_im_3_4 0 s3 x12_im_a4 0 -509187118.9495263
Gd3_5 0 s3 p5 0 -3.092511660828315e-07
Fd3_5 0 s3 V5 -1.5462558304141574e-05
Gr1_3_5 0 s3 x1_a5 0 1757102321056.3154
Gr2_re_3_5 0 s3 x2_re_a5 0 -11429376007.907711
Gr2_im_3_5 0 s3 x2_im_a5 0 -38612437417.29682
Gr3_re_3_5 0 s3 x3_re_a5 0 16914229332.546633
Gr3_im_3_5 0 s3 x3_im_a5 0 25580756511.71749
Gr4_re_3_5 0 s3 x4_re_a5 0 -44266538028.373184
Gr4_im_3_5 0 s3 x4_im_a5 0 -168306644563.50067
Gr5_re_3_5 0 s3 x5_re_a5 0 -14806382254.726055
Gr5_im_3_5 0 s3 x5_im_a5 0 17178836259.682331
Gr6_re_3_5 0 s3 x6_re_a5 0 146881269.36294666
Gr6_im_3_5 0 s3 x6_im_a5 0 197295282.0368261
Gr7_re_3_5 0 s3 x7_re_a5 0 547987424684.069
Gr7_im_3_5 0 s3 x7_im_a5 0 11075114648.816908
Gr8_3_5 0 s3 x8_a5 0 -1237468223050.074
Gr9_re_3_5 0 s3 x9_re_a5 0 -107980755417.5869
Gr9_im_3_5 0 s3 x9_im_a5 0 -273230551323.01108
Gr10_3_5 0 s3 x10_a5 0 9622344737.44569
Gr11_re_3_5 0 s3 x11_re_a5 0 -683965647.9926602
Gr11_im_3_5 0 s3 x11_im_a5 0 -114468726.57130247
Gr12_re_3_5 0 s3 x12_re_a5 0 -84007031.09035787
Gr12_im_3_5 0 s3 x12_im_a5 0 -97800770.04661484
Gd3_6 0 s3 p6 0 -1.929507412958692e-07
Fd3_6 0 s3 V6 -9.64753706479346e-06
Gr1_3_6 0 s3 x1_a6 0 401572335798.5076
Gr2_re_3_6 0 s3 x2_re_a6 0 23035939520.11762
Gr2_im_3_6 0 s3 x2_im_a6 0 -53500285953.11295
Gr3_re_3_6 0 s3 x3_re_a6 0 63023654851.60153
Gr3_im_3_6 0 s3 x3_im_a6 0 150286134655.97986
Gr4_re_3_6 0 s3 x4_re_a6 0 28500359664.56549
Gr4_im_3_6 0 s3 x4_im_a6 0 -287637463924.56494
Gr5_re_3_6 0 s3 x5_re_a6 0 -9506759556.246986
Gr5_im_3_6 0 s3 x5_im_a6 0 22614136727.541992
Gr6_re_3_6 0 s3 x6_re_a6 0 135365545.2663468
Gr6_im_3_6 0 s3 x6_im_a6 0 474158978.2944504
Gr7_re_3_6 0 s3 x7_re_a6 0 1066061032980.3162
Gr7_im_3_6 0 s3 x7_im_a6 0 74659654637.88127
Gr8_3_6 0 s3 x8_a6 0 -2314794605270.1377
Gr9_re_3_6 0 s3 x9_re_a6 0 -117704466655.798
Gr9_im_3_6 0 s3 x9_im_a6 0 -587823402520.7964
Gr10_3_6 0 s3 x10_a6 0 19139646839.930614
Gr11_re_3_6 0 s3 x11_re_a6 0 -1352210472.8731453
Gr11_im_3_6 0 s3 x11_im_a6 0 -255603381.97388065
Gr12_re_3_6 0 s3 x12_re_a6 0 -164691426.83216125
Gr12_im_3_6 0 s3 x12_im_a6 0 -174336148.74997604
Gd3_7 0 s3 p7 0 -1.0528672625026827e-06
Fd3_7 0 s3 V7 -5.264336312513413e-05
Gr1_3_7 0 s3 x1_a7 0 -1232476166082.83
Gr2_re_3_7 0 s3 x2_re_a7 0 -18659851561.268818
Gr2_im_3_7 0 s3 x2_im_a7 0 -6347494372.041812
Gr3_re_3_7 0 s3 x3_re_a7 0 -249651047083.11072
Gr3_im_3_7 0 s3 x3_im_a7 0 -203962638633.6297
Gr4_re_3_7 0 s3 x4_re_a7 0 323823158138.0379
Gr4_im_3_7 0 s3 x4_im_a7 0 576294176336.8414
Gr5_re_3_7 0 s3 x5_re_a7 0 -68200348852.08852
Gr5_im_3_7 0 s3 x5_im_a7 0 -9305933317.304142
Gr6_re_3_7 0 s3 x6_re_a7 0 -2665432324.9790473
Gr6_im_3_7 0 s3 x6_im_a7 0 -1944953495.1697977
Gr7_re_3_7 0 s3 x7_re_a7 0 -2773660031926.225
Gr7_im_3_7 0 s3 x7_im_a7 0 -102121774431.23515
Gr8_3_7 0 s3 x8_a7 0 5551442275121.285
Gr9_re_3_7 0 s3 x9_re_a7 0 440227220755.87213
Gr9_im_3_7 0 s3 x9_im_a7 0 1398521352541.2686
Gr10_3_7 0 s3 x10_a7 0 -41668081800.97568
Gr11_re_3_7 0 s3 x11_re_a7 0 2993855196.3324437
Gr11_im_3_7 0 s3 x11_im_a7 0 512032607.3855636
Gr12_re_3_7 0 s3 x12_re_a7 0 361839102.81258523
Gr12_im_3_7 0 s3 x12_im_a7 0 357117044.61292046
Gd3_8 0 s3 p8 0 1.873092398844583e-06
Fd3_8 0 s3 V8 9.365461994222915e-05
Gr1_3_8 0 s3 x1_a8 0 866320819030.7302
Gr2_re_3_8 0 s3 x2_re_a8 0 -49766620949.46712
Gr2_im_3_8 0 s3 x2_im_a8 0 -21223036736.1011
Gr3_re_3_8 0 s3 x3_re_a8 0 258906931286.0849
Gr3_im_3_8 0 s3 x3_im_a8 0 86117724065.07619
Gr4_re_3_8 0 s3 x4_re_a8 0 -326342356859.57556
Gr4_im_3_8 0 s3 x4_im_a8 0 -249394307480.40405
Gr5_re_3_8 0 s3 x5_re_a8 0 -2414508943.2014546
Gr5_im_3_8 0 s3 x5_im_a8 0 18739018973.33932
Gr6_re_3_8 0 s3 x6_re_a8 0 2505998012.208831
Gr6_im_3_8 0 s3 x6_im_a8 0 1421370169.8886757
Gr7_re_3_8 0 s3 x7_re_a8 0 1620983914121.281
Gr7_im_3_8 0 s3 x7_im_a8 0 46871701741.98491
Gr8_3_8 0 s3 x8_a8 0 -3098488770903.5337
Gr9_re_3_8 0 s3 x9_re_a8 0 -248694784002.06552
Gr9_im_3_8 0 s3 x9_im_a8 0 -727383323714.7064
Gr10_3_8 0 s3 x10_a8 0 23301779882.465847
Gr11_re_3_8 0 s3 x11_re_a8 0 -1787303522.529194
Gr11_im_3_8 0 s3 x11_im_a8 0 -369786266.87350947
Gr12_re_3_8 0 s3 x12_re_a8 0 -227960358.97346097
Gr12_im_3_8 0 s3 x12_im_a8 0 -222320674.45867088
*
* State networks driven by port 3
Cx1_a3 x1_a3 0 1.0
Gx1_a3 0 x1_a3 p3 0 0.07071067811865475
Fx1_a3 0 x1_a3 V3 3.5355339059327378
Rp1_a3 0 x1_a3 9.217407145044509e-14
Cx2_re_a3 x2_re_a3 0 1.0
Gx2_re_a3 0 x2_re_a3 p3 0 0.1414213562373095
Fx2_re_a3 0 x2_re_a3 V3 7.0710678118654755
Rp2_re_re_a3 0 x2_re_a3 1.0786132166118383e-12
Gp2_re_im_a3 0 x2_re_a3 x2_im_a3 0 5111233610923.186
Cx2_im_a3 x2_im_a3 0 1.0
Gp2_im_re_a3 0 x2_im_a3 x2_re_a3 0 -5111233610923.186
Rp2_im_im_a3 0 x2_im_a3 1.0786132166118383e-12
Cx3_re_a3 x3_re_a3 0 1.0
Gx3_re_a3 0 x3_re_a3 p3 0 0.1414213562373095
Fx3_re_a3 0 x3_re_a3 V3 7.0710678118654755
Rp3_re_re_a3 0 x3_re_a3 9.88767760173926e-13
Gp3_re_im_a3 0 x3_re_a3 x3_im_a3 0 3508473312410.142
Cx3_im_a3 x3_im_a3 0 1.0
Gp3_im_re_a3 0 x3_im_a3 x3_re_a3 0 -3508473312410.142
Rp3_im_im_a3 0 x3_im_a3 9.88767760173926e-13
Cx4_re_a3 x4_re_a3 0 1.0
Gx4_re_a3 0 x4_re_a3 p3 0 0.1414213562373095
Fx4_re_a3 0 x4_re_a3 V3 7.0710678118654755
Rp4_re_re_a3 0 x4_re_a3 8.533325723003939e-13
Gp4_re_im_a3 0 x4_re_a3 x4_im_a3 0 2766197540793.715
Cx4_im_a3 x4_im_a3 0 1.0
Gp4_im_re_a3 0 x4_im_a3 x4_re_a3 0 -2766197540793.715
Rp4_im_im_a3 0 x4_im_a3 8.533325723003939e-13
Cx5_re_a3 x5_re_a3 0 1.0
Gx5_re_a3 0 x5_re_a3 p3 0 0.1414213562373095
Fx5_re_a3 0 x5_re_a3 V3 7.0710678118654755
Rp5_re_re_a3 0 x5_re_a3 2.410991705178112e-12
Gp5_re_im_a3 0 x5_re_a3 x5_im_a3 0 2874456996728.0483
Cx5_im_a3 x5_im_a3 0 1.0
Gp5_im_re_a3 0 x5_im_a3 x5_re_a3 0 -2874456996728.0483
Rp5_im_im_a3 0 x5_im_a3 2.410991705178112e-12
Cx6_re_a3 x6_re_a3 0 1.0
Gx6_re_a3 0 x6_re_a3 p3 0 0.1414213562373095
Fx6_re_a3 0 x6_re_a3 V3 7.0710678118654755
Rp6_re_re_a3 0 x6_re_a3 1.6191077353663697e-11
Gp6_re_im_a3 0 x6_re_a3 x6_im_a3 0 2387826528783.5156
Cx6_im_a3 x6_im_a3 0 1.0
Gp6_im_re_a3 0 x6_im_a3 x6_re_a3 0 -2387826528783.5156
Rp6_im_im_a3 0 x6_im_a3 1.6191077353663697e-11
Cx7_re_a3 x7_re_a3 0 1.0
Gx7_re_a3 0 x7_re_a3 p3 0 0.1414213562373095
Fx7_re_a3 0 x7_re_a3 V3 7.0710678118654755
Rp7_re_re_a3 0 x7_re_a3 1.1670965837274465e-12
Gp7_re_im_a3 0 x7_re_a3 x7_im_a3 0 590648106330.5088
Cx7_im_a3 x7_im_a3 0 1.0
Gp7_im_re_a3 0 x7_im_a3 x7_re_a3 0 -590648106330.5088
Rp7_im_im_a3 0 x7_im_a3 1.1670965837274465e-12
Cx8_a3 x8_a3 0 1.0
Gx8_a3 0 x8_a3 p3 0 0.07071067811865475
Fx8_a3 0 x8_a3 V3 3.5355339059327378
Rp8_a3 0 x8_a3 1.057099515142882e-12
Cx9_re_a3 x9_re_a3 0 1.0
Gx9_re_a3 0 x9_re_a3 p3 0 0.1414213562373095
Fx9_re_a3 0 x9_re_a3 V3 7.0710678118654755
Rp9_re_re_a3 0 x9_re_a3 1.5534303609826191e-12
Gp9_re_im_a3 0 x9_re_a3 x9_im_a3 0 455649394468.80255
Cx9_im_a3 x9_im_a3 0 1.0
Gp9_im_re_a3 0 x9_im_a3 x9_re_a3 0 -455649394468.80255
Rp9_im_im_a3 0 x9_im_a3 1.5534303609826191e-12
Cx10_a3 x10_a3 0 1.0
Gx10_a3 0 x10_a3 p3 0 0.07071067811865475
Fx10_a3 0 x10_a3 V3 3.5355339059327378
Rp10_a3 0 x10_a3 5.21381713713202e-12
Cx11_re_a3 x11_re_a3 0 1.0
Gx11_re_a3 0 x11_re_a3 p3 0 0.1414213562373095
Fx11_re_a3 0 x11_re_a3 V3 7.0710678118654755
Rp11_re_re_a3 0 x11_re_a3 1.673721870740383e-11
Gp11_re_im_a3 0 x11_re_a3 x11_im_a3 0 51505589949.64772
Cx11_im_a3 x11_im_a3 0 1.0
Gp11_im_re_a3 0 x11_im_a3 x11_re_a3 0 -51505589949.64772
Rp11_im_im_a3 0 x11_im_a3 1.673721870740383e-11
Cx12_re_a3 x12_re_a3 0 1.0
Gx12_re_a3 0 x12_re_a3 p3 0 0.1414213562373095
Fx12_re_a3 0 x12_re_a3 V3 7.0710678118654755
Rp12_re_re_a3 0 x12_re_a3 6.344273526229328e-11
Gp12_re_im_a3 0 x12_re_a3 x12_im_a3 0 6300408112.88573
Cx12_im_a3 x12_im_a3 0 1.0
Gp12_im_re_a3 0 x12_im_a3 x12_re_a3 0 -6300408112.88573
Rp12_im_im_a3 0 x12_im_a3 6.344273526229328e-11
*
* Port network for port 4
V4 p4 s4 0
R4 s4 0 50.0
Gd4_1 0 s4 p1 0 1.168302145904132e-06
Fd4_1 0 s4 V1 5.841510729520661e-05
Gr1_4_1 0 s4 x1_a1 0 873253897436.3354
Gr2_re_4_1 0 s4 x2_re_a1 0 7573092476.162393
Gr2_im_4_1 0 s4 x2_im_a1 0 -17381753922.135975
Gr3_re_4_1 0 s4 x3_re_a1 0 -104155641823.19276
Gr3_im_4_1 0 s4 x3_im_a1 0 -44430346490.11576
Gr4_re_4_1 0 s4 x4_re_a1 0 -30865975530.60318
Gr4_im_4_1 0 s4 x4_im_a1 0 61283172042.856026
Gr5_re_4_1 0 s4 x5_re_a1 0 -33177692021.947556
Gr5_im_4_1 0 s4 x5_im_a1 0 5460040301.101243
Gr6_re_4_1 0 s4 x6_re_a1 0 -39349714.86878474
Gr6_im_4_1 0 s4 x6_im_a1 0 -147315730.22817835
Gr7_re_4_1 0 s4 x7_re_a1 0 -244073150360.13074
Gr7_im_4_1 0 s4 x7_im_a1 0 42642330946.78582
Gr8_4_1 0 s4 x8_a1 0 539813955704.85504
Gr9_re_4_1 0 s4 x9_re_a1 0 43024872700.476845
Gr9_im_4_1 0 s4 x9_im_a1 0 86953324642.00877
Gr10_4_1 0 s4 x10_a1 0 132241649.01378575
Gr11_re_4_1 0 s4 x11_re_a1 0 -162669768.50424328
Gr11_im_4_1 0 s4 x11_im_a1 0 -132723808.57235944
Gr12_re_4_1 0 s4 x12_re_a1 0 -32979683.58917622
Gr12_im_4_1 0 s4 x12_im_a1 0 -40661404.56497674
Gd4_2 0 s4 p2 0 1.3313692013650069e-06
Fd4_2 0 s4 V2 6.656846006825035e-05
Gr1_4_2 0 s4 x1_a2 0 99851976858.45157
Gr2_re_4_2 0 s4 x2_re_a2 0 15488938034.71509
Gr2_im_4_2 0 s4 x2_im_a2 0 -22219753034.060986
Gr3_re_4_2 0 s4 x3_re_a2 0 -100891523606.04225
Gr3_im_4_2 0 s4 x3_im_a2 0 -19785668092.11014
Gr4_re_4_2 0 s4 x4_re_a2 0 -48651982073.16408
Gr4_im_4_2 0 s4 x4_im_a2 0 100022718832.38602
Gr5_re_4_2 0 s4 x5_re_a2 0 -25943701934.977966
Gr5_im_4_2 0 s4 x5_im_a2 0 10018848942.611378
Gr6_re_4_2 0 s4 x6_re_a2 0 17941418.949455336
Gr6_im_4_2 0 s4 x6_im_a2 0 -230671177.76830238
Gr7_re_4_2 0 s4 x7_re_a2 0 -451434003536.903
Gr7_im_4_2 0 s4 x7_im_a2 0 -80628906600.04747
Gr8_4_2 0 s4 x8_a2 0 1033487375392.4497
Gr9_re_4_2 0 s4 x9_re_a2 0 63646939265.3023
Gr9_im_4_2 0 s4 x9_im_a2 0 243704056195.4081
Gr10_4_2 0 s4 x10_a2 0 -9598745179.42459
Gr11_re_4_2 0 s4 x11_re_a2 0 723228868.9845359
Gr11_im_4_2 0 s4 x11_im_a2 0 121275118.86098295
Gr12_re_4_2 0 s4 x12_re_a2 0 88439956.54558785
Gr12_im_4_2 0 s4 x12_im_a2 0 94434139.50938985
Gd4_3 0 s4 p3 0 1.3056178841308608e-06
Fd4_3 0 s4 V3 6.528089420654304e-05
Gr1_4_3 0 s4 x1_a3 0 2416742876261.728
Gr2_re_4_3 0 s4 x2_re_a3 0 -118241995048.32513
Gr2_im_4_3 0 s4 x2_im_a3 0 -15550466514.066092
Gr3_re_4_3 0 s4 x3_re_a3 0 595058158262.745
Gr3_im_4_3 0 s4 x3_im_a3 0 121007732555.02603
Gr4_re_4_3 0 s4 x4_re_a3 0 -367793658596.4161
Gr4_im_4_3 0 s4 x4_im_a3 0 -804745004397.8853
Gr5_re_4_3 0 s4 x5_re_a3 0 31617746491.06684
Gr5_im_4_3 0 s4 x5_im_a3 0 40397042204.442154
Gr6_re_4_3 0 s4 x6_re_a3 0 2781111087.0831237
Gr6_im_4_3 0 s4 x6_im_a3 0 1401733657.2070608
Gr7_re_4_3 0 s4 x7_re_a3 0 3020850164633.3315
Gr7_im_4_3 0 s4 x7_im_a3 0 -78976593325.59172
Gr8_4_3 0 s4 x8_a3 0 -6791170089601.152
Gr9_re_4_3 0 s4 x9_re_a3 0 -493888459716.0391
Gr9_im_4_3 0 s4 x9_im_a3 0 -1814779829811.3503
Gr10_4_3 0 s4 x10_a3 0 55664992258.831055
Gr11_re_4_3 0 s4 x11_re_a3 0 -3895516982.836969
Gr11_im_4_3 0 s4 x11_im_a3 0 -703526088.7180196
Gr12_re_4_3 0 s4 x12_re_a3 0 -466017119.8625733
Gr12_im_4_3 0 s4 x12_im_a3 0 -509187118.9496066
Gd4_4 0 s4 p4 0 -1.3249095641099108e-06
Fd4_4 0 s4 V4 -6.624547820549555e-05
Gr1_4_4 0 s4 x1_a4 0 -4322958832065.7397
Gr2_re_4_4 0 s4 x2_re_a4 0 299968911042.2593
Gr2_im_4_4 0 s4 x2_im_a4 0 -3099568318.4968433
Gr3_re_4_4 0 s4 x3_re_a4 0 -210416786362.5903
Gr3_im_4_4 0 s4 x3_im_a4 0 -111520467779.23384
Gr4_re_4_4 0 s4 x4_re_a4 0 394658553423.4903
Gr4_im_4_4 0 s4 x4_im_a4 0 270459023739.62973
Gr5_re_4_4 0 s4 x5_re_a4 0 -53258064877.87936
Gr5_im_4_4 0 s4 x5_im_a4 0 18819561283.436783
Gr6_re_4_4 0 s4 x6_re_a4 0 -2594704539.3221235
Gr6_im_4_4 0 s4 x6_im_a4 0 -509914357.94702345
Gr7_re_4_4 0 s4 x7_re_a4 0 -1100549393565.7112
Gr7_im_4_4 0 s4 x7_im_a4 0 323829208682.4129
Gr8_4_4 0 s4 x8_a4 0 2694589911531.888
Gr9_re_4_4 0 s4 x9_re_a4 0 266578797559.24933
Gr9_im_4_4 0 s4 x9_im_a4 0 647116598664.6937
Gr10_4_4 0 s4 x10_a4 0 -17656592377.200615
Gr11_re_4_4 0 s4 x11_re_a4 0 1093314284.5421631
Gr11_im_4_4 0 s4 x11_im_a4 0 146890868.2280386
Gr12_re_4_4 0 s4 x12_re_a4 0 115683542.72524364
Gr12_im_4_4 0 s4 x12_im_a4 0 127766437.74483104
Gd4_5 0 s4 p5 0 -1.5669580957512405e-07
Fd4_5 0 s4 V5 -7.834790478756203e-06
Gr1_4_5 0 s4 x1_a5 0 1760378054265.6765
Gr2_re_4_5 0 s4 x2_re_a5 0 -12318477889.515318
Gr2_im_4_5 0 s4 x2_im_a5 0 -39224006275.504425
Gr3_re_4_5 0 s4 x3_re_a5 0 16025015731.294025
Gr3_im_4_5 0 s4 x3_im_a5 0 25940778918.378174
Gr4_re_4_5 0 s4 x4_re_a5 0 -43871601276.89051
Gr4_im_4_5 0 s4 x4_im_a5 0 -167382944139.866
Gr5_re_4_5 0 s4 x5_re_a5 0 -14820212920.425
Gr5_im_4_5 0 s4 x5_im_a5 0 17168489449.929781
Gr6_re_4_5 0 s4 x6_re_a5 0 147374892.68972543
Gr6_im_4_5 0 s4 x6_im_a5 0 197375411.36147282
Gr7_re_4_5 0 s4 x7_re_a5 0 544881964495.3487
Gr7_im_4_5 0 s4 x7_im_a5 0 10987750045.847672
Gr8_4_5 0 s4 x8_a5 0 -1230940176735.1292
Gr9_re_4_5 0 s4 x9_re_a5 0 -107519277921.60623
Gr9_im_4_5 0 s4 x9_im_a5 0 -271502647871.23987
Gr10_4_5 0 s4 x10_a5 0 9576681518.743551
Gr11_re_4_5 0 s4 x11_re_a5 0 -682122260.9074423
Gr11_im_4_5 0 s4 x11_im_a5 0 -115270624.87802103
Gr12_re_4_5 0 s4 x12_re_a5 0 -83693586.95231082
Gr12_im_4_5 0 s4 x12_im_a5 0 -97030337.0581865
Gd4_6 0 s4 p6 0 3.4458404744395344e-08
Fd4_6 0 s4 V6 1.7229202372197672e-06
Gr1_4_6 0 s4 x1_a6 0 396017401297.0695
Gr2_re_4_6 0 s4 x2_re_a6 0 23272078105.22252
Gr2_im_4_6 0 s4 x2_im_a6 0 -52960058218.80644
Gr3_re_4_6 0 s4 x3_re_a6 0 63338345342.24266
Gr3_im_4_6 0 s4 x3_im_a6 0 150082878458.7337
Gr4_re_4_6 0 s4 x4_re_a6 0 28522591350.40876
Gr4_im_4_6 0 s4 x4_im_a6 0 -287085178021.9242
Gr5_re_4_6 0 s4 x5_re_a6 0 -9533882764.326567
Gr5_im_4_6 0 s4 x5_im_a6 0 22553908085.328526
Gr6_re_4_6 0 s4 x6_re_a6 0 135902480.04312822
Gr6_im_4_6 0 s4 x6_im_a6 0 473455279.87363356
Gr7_re_4_6 0 s4 x7_re_a6 0 1061357009242.284
Gr7_im_4_6 0 s4 x7_im_a6 0 74630460182.03952
Gr8_4_6 0 s4 x8_a6 0 -2304204591066.7446
Gr9_re_4_6 0 s4 x9_re_a6 0 -117072665613.63455
Gr9_im_4_6 0 s4 x9_im_a6 0 -585152515814.2979
Gr10_4_6 0 s4 x10_a6 0 19036342259.264755
Gr11_re_4_6 0 s4 x11_re_a6 0 -1343632341.529324
Gr11_im_4_6 0 s4 x11_im_a6 0 -253141322.45594218
Gr12_re_4_6 0 s4 x12_re_a6 0 -163541945.62583378
Gr12_im_4_6 0 s4 x12_im_a6 0 -173029966.61876187
Gd4_7 0 s4 p7 0 1.961073330092192e-06
Fd4_7 0 s4 V7 9.80536665046096e-05
Gr1_4_7 0 s4 x1_a7 0 853800103805.6635
Gr2_re_4_7 0 s4 x2_re_a7 0 -48722414413.29814
Gr2_im_4_7 0 s4 x2_im_a7 0 -19754668966.635876
Gr3_re_4_7 0 s4 x3_re_a7 0 260547980995.64658
Gr3_im_4_7 0 s4 x3_im_a7 0 86581748697.53978
Gr4_re_4_7 0 s4 x4_re_a7 0 -326108435340.2812
Gr4_im_4_7 0 s4 x4_im_a7 0 -250763631872.24188
Gr5_re_4_7 0 s4 x5_re_a7 0 -2345402011.742276
Gr5_im_4_7 0 s4 x5_im_a7 0 18732789803.717335
Gr6_re_4_7 0 s4 x6_re_a7 0 2507864266.0242705
Gr6_im_4_7 0 s4 x6_im_a7 0 1422114992.5065253
Gr7_re_4_7 0 s4 x7_re_a7 0 1620233919028.0623
Gr7_im_4_7 0 s4 x7_im_a7 0 47507000575.90687
Gr8_4_7 0 s4 x8_a7 0 -3096119334837.146
Gr9_re_4_7 0 s4 x9_re_a7 0 -248405030211.79626
Gr9_im_4_7 0 s4 x9_im_a7 0 -727070321105.6428
Gr10_4_7 0 s4 x10_a7 0 23286652567.635025
Gr11_re_4_7 0 s4 x11_re_a7 0 -1785847657.0848076
Gr11_im_4_7 0 s4 x11_im_a7 0 -369998650.214372
Gr12_re_4_7 0 s4 x12_re_a7 0 -228000178.73281437
Gr12_im_4_7 0 s4 x12_im_a7 0 -222371529.9242958
Gd4_8 0 s4 p8 0 -1.4016081950476554e-06
Fd4_8 0 s4 V8 -7.008040975238277e-05
Gr1_4_8 0 s4 x1_a8 0 -1227080303049.6152
Gr2_re_4_8 0 s4 x2_re_a8 0 -18503937930.50685
Gr2_im_4_8 0 s4 x2_im_a8 0 -6830212328.370883
Gr3_re_4_8 0 s4 x3_re_a8 0 -249162851386.74106
Gr3_im_4_8 0 s4 x3_im_a8 0 -203919158933.29797
Gr4_re_4_8 0 s4 x4_re_a8 0 323136540232.4661
Gr4_im_4_8 0 s4 x4_im_a8 0 574900133639.917
Gr5_re_4_8 0 s4 x5_re_a8 0 -68092785294.46551
Gr5_im_4_8 0 s4 x5_im_a8 0 -9271637706.690123
Gr6_re_4_8 0 s4 x6_re_a8 0 -2668324483.860993
Gr6_im_4_8 0 s4 x6_im_a8 0 -1943100093.658145
Gr7_re_4_8 0 s4 x7_re_a8 0 -2765041681291.1035
Gr7_im_4_8 0 s4 x7_im_a8 0 -102303240710.67914
Gr8_4_8 0 s4 x8_a8 0 5532825472361.3545
Gr9_re_4_8 0 s4 x9_re_a8 0 438804116929.0387
Gr9_im_4_8 0 s4 x9_im_a8 0 1393808041749.1294
Gr10_4_8 0 s4 x10_a8 0 -41526339891.33134
Gr11_re_4_8 0 s4 x11_re_a8 0 2984470298.5288
Gr11_im_4_8 0 s4 x11_im_a8 0 511731211.9051449
Gr12_re_4_8 0 s4 x12_re_a8 0 360875327.16315705
Gr12_im_4_8 0 s4 x12_im_a8 0 356017444.51463157
*
* State networks driven by port 4
Cx1_a4 x1_a4 0 1.0
Gx1_a4 0 x1_a4 p4 0 0.07071067811865475
Fx1_a4 0 x1_a4 V4 3.5355339059327378
Rp1_a4 0 x1_a4 9.217407145044509e-14
Cx2_re_a4 x2_re_a4 0 1.0
Gx2_re_a4 0 x2_re_a4 p4 0 0.1414213562373095
Fx2_re_a4 0 x2_re_a4 V4 7.0710678118654755
Rp2_re_re_a4 0 x2_re_a4 1.0786132166118383e-12
Gp2_re_im_a4 0 x2_re_a4 x2_im_a4 0 5111233610923.186
Cx2_im_a4 x2_im_a4 0 1.0
Gp2_im_re_a4 0 x2_im_a4 x2_re_a4 0 -5111233610923.186
Rp2_im_im_a4 0 x2_im_a4 1.0786132166118383e-12
Cx3_re_a4 x3_re_a4 0 1.0
Gx3_re_a4 0 x3_re_a4 p4 0 0.1414213562373095
Fx3_re_a4 0 x3_re_a4 V4 7.0710678118654755
Rp3_re_re_a4 0 x3_re_a4 9.88767760173926e-13
Gp3_re_im_a4 0 x3_re_a4 x3_im_a4 0 3508473312410.142
Cx3_im_a4 x3_im_a4 0 1.0
Gp3_im_re_a4 0 x3_im_a4 x3_re_a4 0 -3508473312410.142
Rp3_im_im_a4 0 x3_im_a4 9.88767760173926e-13
Cx4_re_a4 x4_re_a4 0 1.0
Gx4_re_a4 0 x4_re_a4 p4 0 0.1414213562373095
Fx4_re_a4 0 x4_re_a4 V4 7.0710678118654755
Rp4_re_re_a4 0 x4_re_a4 8.533325723003939e-13
Gp4_re_im_a4 0 x4_re_a4 x4_im_a4 0 2766197540793.715
Cx4_im_a4 x4_im_a4 0 1.0
Gp4_im_re_a4 0 x4_im_a4 x4_re_a4 0 -2766197540793.715
Rp4_im_im_a4 0 x4_im_a4 8.533325723003939e-13
Cx5_re_a4 x5_re_a4 0 1.0
Gx5_re_a4 0 x5_re_a4 p4 0 0.1414213562373095
Fx5_re_a4 0 x5_re_a4 V4 7.0710678118654755
Rp5_re_re_a4 0 x5_re_a4 2.410991705178112e-12
Gp5_re_im_a4 0 x5_re_a4 x5_im_a4 0 2874456996728.0483
Cx5_im_a4 x5_im_a4 0 1.0
Gp5_im_re_a4 0 x5_im_a4 x5_re_a4 0 -2874456996728.0483
Rp5_im_im_a4 0 x5_im_a4 2.410991705178112e-12
Cx6_re_a4 x6_re_a4 0 1.0
Gx6_re_a4 0 x6_re_a4 p4 0 0.1414213562373095
Fx6_re_a4 0 x6_re_a4 V4 7.0710678118654755
Rp6_re_re_a4 0 x6_re_a4 1.6191077353663697e-11
Gp6_re_im_a4 0 x6_re_a4 x6_im_a4 0 2387826528783.5156
Cx6_im_a4 x6_im_a4 0 1.0
Gp6_im_re_a4 0 x6_im_a4 x6_re_a4 0 -2387826528783.5156
Rp6_im_im_a4 0 x6_im_a4 1.6191077353663697e-11
Cx7_re_a4 x7_re_a4 0 1.0
Gx7_re_a4 0 x7_re_a4 p4 0 0.1414213562373095
Fx7_re_a4 0 x7_re_a4 V4 7.0710678118654755
Rp7_re_re_a4 0 x7_re_a4 1.1670965837274465e-12
Gp7_re_im_a4 0 x7_re_a4 x7_im_a4 0 590648106330.5088
Cx7_im_a4 x7_im_a4 0 1.0
Gp7_im_re_a4 0 x7_im_a4 x7_re_a4 0 -590648106330.5088
Rp7_im_im_a4 0 x7_im_a4 1.1670965837274465e-12
Cx8_a4 x8_a4 0 1.0
Gx8_a4 0 x8_a4 p4 0 0.07071067811865475
Fx8_a4 0 x8_a4 V4 3.5355339059327378
Rp8_a4 0 x8_a4 1.057099515142882e-12
Cx9_re_a4 x9_re_a4 0 1.0
Gx9_re_a4 0 x9_re_a4 p4 0 0.1414213562373095
Fx9_re_a4 0 x9_re_a4 V4 7.0710678118654755
Rp9_re_re_a4 0 x9_re_a4 1.5534303609826191e-12
Gp9_re_im_a4 0 x9_re_a4 x9_im_a4 0 455649394468.80255
Cx9_im_a4 x9_im_a4 0 1.0
Gp9_im_re_a4 0 x9_im_a4 x9_re_a4 0 -455649394468.80255
Rp9_im_im_a4 0 x9_im_a4 1.5534303609826191e-12
Cx10_a4 x10_a4 0 1.0
Gx10_a4 0 x10_a4 p4 0 0.07071067811865475
Fx10_a4 0 x10_a4 V4 3.5355339059327378
Rp10_a4 0 x10_a4 5.21381713713202e-12
Cx11_re_a4 x11_re_a4 0 1.0
Gx11_re_a4 0 x11_re_a4 p4 0 0.1414213562373095
Fx11_re_a4 0 x11_re_a4 V4 7.0710678118654755
Rp11_re_re_a4 0 x11_re_a4 1.673721870740383e-11
Gp11_re_im_a4 0 x11_re_a4 x11_im_a4 0 51505589949.64772
Cx11_im_a4 x11_im_a4 0 1.0
Gp11_im_re_a4 0 x11_im_a4 x11_re_a4 0 -51505589949.64772
Rp11_im_im_a4 0 x11_im_a4 1.673721870740383e-11
Cx12_re_a4 x12_re_a4 0 1.0
Gx12_re_a4 0 x12_re_a4 p4 0 0.1414213562373095
Fx12_re_a4 0 x12_re_a4 V4 7.0710678118654755
Rp12_re_re_a4 0 x12_re_a4 6.344273526229328e-11
Gp12_re_im_a4 0 x12_re_a4 x12_im_a4 0 6300408112.88573
Cx12_im_a4 x12_im_a4 0 1.0
Gp12_im_re_a4 0 x12_im_a4 x12_re_a4 0 -6300408112.88573
Rp12_im_im_a4 0 x12_im_a4 6.344273526229328e-11
*
* Port network for port 5
V5 p5 s5 0
R5 s5 0 50.0
Gd5_1 0 s5 p1 0 3.4628440887226124e-07
Fd5_1 0 s5 V1 1.731422044361306e-05
Gr1_5_1 0 s5 x1_a1 0 382557379978.0057
Gr2_re_5_1 0 s5 x2_re_a1 0 -10586348267.878819
Gr2_im_5_1 0 s5 x2_im_a1 0 6609100857.421738
Gr3_re_5_1 0 s5 x3_re_a1 0 13923877715.751734
Gr3_im_5_1 0 s5 x3_im_a1 0 -100341859927.88763
Gr4_re_5_1 0 s5 x4_re_a1 0 -34773609758.316284
Gr4_im_5_1 0 s5 x4_im_a1 0 158539265941.4521
Gr5_re_5_1 0 s5 x5_re_a1 0 -37673065805.86035
Gr5_im_5_1 0 s5 x5_im_a1 0 -1486687383.7469022
Gr6_re_5_1 0 s5 x6_re_a1 0 -49422169.53508685
Gr6_im_5_1 0 s5 x6_im_a1 0 -291184051.2517911
Gr7_re_5_1 0 s5 x7_re_a1 0 -689255712892.8203
Gr7_im_5_1 0 s5 x7_im_a1 0 -76449687744.49007
Gr8_5_1 0 s5 x8_a1 0 1664206556004.0457
Gr9_re_5_1 0 s5 x9_re_a1 0 35130769343.37159
Gr9_im_5_1 0 s5 x9_im_a1 0 513194478951.8239
Gr10_5_1 0 s5 x10_a1 0 -14442973803.05097
Gr11_re_5_1 0 s5 x11_re_a1 0 1036847869.2779179
Gr11_im_5_1 0 s5 x11_im_a1 0 196989436.9268784
Gr12_re_5_1 0 s5 x12_re_a1 0 119317195.20586954
Gr12_im_5_1 0 s5 x12_im_a1 0 116956440.58399922
Gd5_2 0 s5 p2 0 2.5426758811140924e-07
Fd5_2 0 s5 V2 1.2713379405570463e-05
Gr1_5_2 0 s5 x1_a2 0 -195496636695.23123
Gr2_re_5_2 0 s5 x2_re_a2 0 -52680366778.617546
Gr2_im_5_2 0 s5 x2_im_a2 0 -19881308837.588005
Gr3_re_5_2 0 s5 x3_re_a2 0 20408589466.75918
Gr3_im_5_2 0 s5 x3_im_a2 0 13123512572.940323
Gr4_re_5_2 0 s5 x4_re_a2 0 49865132032.877205
Gr4_im_5_2 0 s5 x4_im_a2 0 70173533080.50156
Gr5_re_5_2 0 s5 x5_re_a2 0 -28499366446.86654
Gr5_im_5_2 0 s5 x5_im_a2 0 17318873392.461285
Gr6_re_5_2 0 s5 x6_re_a2 0 -101555379.69420668
Gr6_im_5_2 0 s5 x6_im_a2 0 -46699534.81633209
Gr7_re_5_2 0 s5 x7_re_a2 0 -212689221893.13943
Gr7_im_5_2 0 s5 x7_im_a2 0 31823109826.06974
Gr8_5_2 0 s5 x8_a2 0 653355114775.0737
Gr9_re_5_2 0 s5 x9_re_a2 0 -68532436742.08349
Gr9_im_5_2 0 s5 x9_im_a2 0 78599233663.93636
Gr10_5_2 0 s5 x10_a2 0 -1255328601.2998528
Gr11_re_5_2 0 s5 x11_re_a2 0 104848303.66450475
Gr11_im_5_2 0 s5 x11_im_a2 0 -24677456.174569324
Gr12_re_5_2 0 s5 x12_re_a2 0 16034970.469042072
Gr12_im_5_2 0 s5 x12_im_a2 0 32944924.225567967
Gd5_3 0 s5 p3 0 -3.092511660828315e-07
Fd5_3 0 s5 V3 -1.5462558304141574e-05
Gr1_5_3 0 s5 x1_a3 0 1757102321056.3057
Gr2_re_5_3 0 s5 x2_re_a3 0 -11429376007.9073
Gr2_im_5_3 0 s5 x2_im_a3 0 -38612437417.29588
Gr3_re_5_3 0 s5 x3_re_a3 0 16914229332.546436
Gr3_im_5_3 0 s5 x3_im_a3 0 25580756511.719288
Gr4_re_5_3 0 s5 x4_re_a3 0 -44266538028.369095
Gr4_im_5_3 0 s5 x4_im_a3 0 -168306644563.50198
Gr5_re_5_3 0 s5 x5_re_a3 0 -14806382254.726229
Gr5_im_5_3 0 s5 x5_im_a3 0 17178836259.682526
Gr6_re_5_3 0 s5 x6_re_a3 0 146881269.36293796
Gr6_im_5_3 0 s5 x6_im_a3 0 197295282.03682697
Gr7_re_5_3 0 s5 x7_re_a3 0 547987424684.1054
Gr7_im_5_3 0 s5 x7_im_a3 0 11075114648.843576
Gr8_5_3 0 s5 x8_a3 0 -1237468223050.1694
Gr9_re_5_3 0 s5 x9_re_a3 0 -107980755417.57791
Gr9_im_5_3 0 s5 x9_im_a3 0 -273230551323.04352
Gr10_5_3 0 s5 x10_a3 0 9622344737.447628
Gr11_re_5_3 0 s5 x11_re_a3 0 -683965647.992833
Gr11_im_5_3 0 s5 x11_im_a3 0 -114468726.57136515
Gr12_re_5_3 0 s5 x12_re_a3 0 -84007031.09037906
Gr12_im_5_3 0 s5 x12_im_a3 0 -97800770.04662666
Gd5_4 0 s5 p4 0 -1.5669580957512405e-07
Fd5_4 0 s5 V4 -7.834790478756203e-06
Gr1_5_4 0 s5 x1_a4 0 1760378054265.687
Gr2_re_5_4 0 s5 x2_re_a4 0 -12318477889.515682
Gr2_im_5_4 0 s5 x2_im_a4 0 -39224006275.505295
Gr3_re_5_4 0 s5 x3_re_a4 0 16025015731.294413
Gr3_im_5_4 0 s5 x3_im_a4 0 25940778918.37651
Gr4_re_5_4 0 s5 x4_re_a4 0 -43871601276.89437
Gr4_im_5_4 0 s5 x4_im_a4 0 -167382944139.8652
Gr5_re_5_4 0 s5 x5_re_a4 0 -14820212920.424843
Gr5_im_5_4 0 s5 x5_im_a4 0 17168489449.929617
Gr6_re_5_4 0 s5 x6_re_a4 0 147374892.68972525
Gr6_im_5_4 0 s5 x6_im_a4 0 197375411.36147094
Gr7_re_5_4 0 s5 x7_re_a4 0 544881964495.3165
Gr7_im_5_4 0 s5 x7_im_a4 0 10987750045.822636
Gr8_5_4 0 s5 x8_a4 0 -1230940176735.045
Gr9_re_5_4 0 s5 x9_re_a4 0 -107519277921.61478
Gr9_im_5_4 0 s5 x9_im_a4 0 -271502647871.21045
Gr10_5_4 0 s5 x10_a4 0 9576681518.741938
Gr11_re_5_4 0 s5 x11_re_a4 0 -682122260.9073193
Gr11_im_5_4 0 s5 x11_im_a4 0 -115270624.87798771
Gr12_re_5_4 0 s5 x12_re_a4 0 -83693586.9522964
Gr12_im_5_4 0 s5 x12_im_a4 0 -97030337.05816765
Gd5_5 0 s5 p5 0 -2.661981297114036e-07
Fd5_5 0 s5 V5 -1.330990648557018e-05
Gr1_5_5 0 s5 x1_a5 0 -1941031394108.54
Gr2_re_5_5 0 s5 x2_re_a5 0 52399277821.13459
Gr2_im_5_5 0 s5 x2_im_a5 0 -10913871265.113482
Gr3_re_5_5 0 s5 x3_re_a5 0 164818979602.856
Gr3_im_5_5 0 s5 x3_im_a5 0 44794704499.855736
Gr4_re_5_5 0 s5 x4_re_a5 0 -8745492075.918365
Gr4_im_5_5 0 s5 x4_im_a5 0 -211540763890.85843
Gr5_re_5_5 0 s5 x5_re_a5 0 -16342968161.382355
Gr5_im_5_5 0 s5 x5_im_a5 0 20539897131.347313
Gr6_re_5_5 0 s5 x6_re_a5 0 69382869.41258468
Gr6_im_5_5 0 s5 x6_im_a5 0 329448252.0335912
Gr7_re_5_5 0 s5 x7_re_a5 0 789921884704.0626
Gr7_im_5_5 0 s5 x7_im_a5 0 137868747240.34357
Gr8_5_5 0 s5 x8_a5 0 -1896488987579.377
Gr9_re_5_5 0 s5 x9_re_a5 0 51061402359.08534
Gr9_im_5_5 0 s5 x9_im_a5 0 -455146872844.1726
Gr10_5_5 0 s5 x10_a5 0 17470928987.622807
Gr11_re_5_5 0 s5 x11_re_a5 0 -1452981899.1367915
Gr11_im_5_5 0 s5 x11_im_a5 0 -301006061.70033014
Gr12_re_5_5 0 s5 x12_re_a5 0 -183675877.01767853
Gr12_im_5_5 0 s5 x12_im_a5 0 -185393004.4211406
Gd5_6 0 s5 p6 0 -4.439799418687329e-07
Fd5_6 0 s5 V6 -2.2198997093436645e-05
Gr1_5_6 0 s5 x1_a6 0 1000225149358.6328
Gr2_re_5_6 0 s5 x2_re_a6 0 -6262048881.276392
Gr2_im_5_6 0 s5 x2_im_a6 0 -50975139824.22368
Gr3_re_5_6 0 s5 x3_re_a6 0 144899393351.12375
Gr3_im_5_6 0 s5 x3_im_a6 0 47757488570.46466
Gr4_re_5_6 0 s5 x4_re_a6 0 -40273297338.574425
Gr4_im_5_6 0 s5 x4_im_a6 0 -112722791676.26285
Gr5_re_5_6 0 s5 x5_re_a6 0 -17771502083.32817
Gr5_im_5_6 0 s5 x5_im_a6 0 8091936105.159883
Gr6_re_5_6 0 s5 x6_re_a6 0 133822009.21947064
Gr6_im_5_6 0 s5 x6_im_a6 0 121490735.6851232
Gr7_re_5_6 0 s5 x7_re_a6 0 350754211044.1971
Gr7_im_5_6 0 s5 x7_im_a6 0 -31564995345.426796
Gr8_5_6 0 s5 x8_a6 0 -903800470428.4077
Gr9_re_5_6 0 s5 x9_re_a6 0 -37854581207.40549
Gr9_im_5_6 0 s5 x9_im_a6 0 -277651833226.58716
Gr10_5_6 0 s5 x10_a6 0 3963041682.764355
Gr11_re_5_6 0 s5 x11_re_a6 0 -177769771.33628556
Gr11_im_5_6 0 s5 x11_im_a6 0 9967116.056028144
Gr12_re_5_6 0 s5 x12_re_a6 0 -18102936.982582126
Gr12_im_5_6 0 s5 x12_im_a6 0 -35965396.5296011
Gd5_7 0 s5 p7 0 7.231157521347952e-07
Fd5_7 0 s5 V7 3.6155787606739764e-05
Gr1_5_7 0 s5 x1_a7 0 136093079652.38812
Gr2_re_5_7 0 s5 x2_re_a7 0 -14743577399.311384
Gr2_im_5_7 0 s5 x2_im_a7 0 4240614462.1519036
Gr3_re_5_7 0 s5 x3_re_a7 0 -131212884209.55179
Gr3_im_5_7 0 s5 x3_im_a7 0 -49819326959.092445
Gr4_re_5_7 0 s5 x4_re_a7 0 -2305700753.7100587
Gr4_im_5_7 0 s5 x4_im_a7 0 132562981943.99776
Gr5_re_5_7 0 s5 x5_re_a7 0 -34377373310.12413
Gr5_im_5_7 0 s5 x5_im_a7 0 3000624980.314004
Gr6_re_5_7 0 s5 x6_re_a7 0 -57379665.07714885
Gr6_im_5_7 0 s5 x6_im_a7 0 -214294663.48476988
Gr7_re_5_7 0 s5 x7_re_a7 0 -492941004208.2337
Gr7_im_5_7 0 s5 x7_im_a7 0 -56051628171.89207
Gr8_5_7 0 s5 x8_a7 0 1127893488849.443
Gr9_re_5_7 0 s5 x9_re_a7 0 75029267740.51279
Gr9_im_5_7 0 s5 x9_im_a7 0 262692469019.59048
Gr10_5_7 0 s5 x10_a7 0 -9931322422.329369
Gr11_re_5_7 0 s5 x11_re_a7 0 751343304.586727
Gr11_im_5_7 0 s5 x11_im_a7 0 132828139.46084146
Gr12_re_5_7 0 s5 x12_re_a7 0 92224529.10508896
Gr12_im_5_7 0 s5 x12_im_a7 0 98224690.29972407
Gd5_8 0 s5 p8 0 4.045078799463919e-07
Fd5_8 0 s5 V8 2.02253939973196e-05
Gr1_5_8 0 s5 x1_a8 0 124597427231.6973
Gr2_re_5_8 0 s5 x2_re_a8 0 -14595919791.207506
Gr2_im_5_8 0 s5 x2_im_a8 0 5851800678.323136
Gr3_re_5_8 0 s5 x3_re_a8 0 -130643403610.82593
Gr3_im_5_8 0 s5 x3_im_a8 0 -48863400389.88882
Gr4_re_5_8 0 s5 x4_re_a8 0 -896011665.8459454
Gr4_im_5_8 0 s5 x4_im_a8 0 132525287823.22142
Gr5_re_5_8 0 s5 x5_re_a8 0 -34405442175.940094
Gr5_im_5_8 0 s5 x5_im_a8 0 2997271881.551215
Gr6_re_5_8 0 s5 x6_re_a8 0 -58483454.10503728
Gr6_im_5_8 0 s5 x6_im_a8 0 -214208548.63116878
Gr7_re_5_8 0 s5 x7_re_a8 0 -498658452502.82135
Gr7_im_5_8 0 s5 x7_im_a8 0 -54996077018.80136
Gr8_5_8 0 s5 x8_a8 0 1141210824604.2974
Gr9_re_5_8 0 s5 x9_re_a8 0 76209135477.57469
Gr9_im_5_8 0 s5 x9_im_a8 0 265613536603.37164
Gr10_5_8 0 s5 x10_a8 0 -10037536355.923061
Gr11_re_5_8 0 s5 x11_re_a8 0 760249084.9358066
Gr11_im_5_8 0 s5 x11_im_a8 0 135112828.18959948
Gr12_re_5_8 0 s5 x12_re_a8 0 93113951.33597164
Gr12_im_5_8 0 s5 x12_im_a8 0 98856820.47841899
*
* State networks driven by port 5
Cx1_a5 x1_a5 0 1.0
Gx1_a5 0 x1_a5 p5 0 0.07071067811865475
Fx1_a5 0 x1_a5 V5 3.5355339059327378
Rp1_a5 0 x1_a5 9.217407145044509e-14
Cx2_re_a5 x2_re_a5 0 1.0
Gx2_re_a5 0 x2_re_a5 p5 0 0.1414213562373095
Fx2_re_a5 0 x2_re_a5 V5 7.0710678118654755
Rp2_re_re_a5 0 x2_re_a5 1.0786132166118383e-12
Gp2_re_im_a5 0 x2_re_a5 x2_im_a5 0 5111233610923.186
Cx2_im_a5 x2_im_a5 0 1.0
Gp2_im_re_a5 0 x2_im_a5 x2_re_a5 0 -5111233610923.186
Rp2_im_im_a5 0 x2_im_a5 1.0786132166118383e-12
Cx3_re_a5 x3_re_a5 0 1.0
Gx3_re_a5 0 x3_re_a5 p5 0 0.1414213562373095
Fx3_re_a5 0 x3_re_a5 V5 7.0710678118654755
Rp3_re_re_a5 0 x3_re_a5 9.88767760173926e-13
Gp3_re_im_a5 0 x3_re_a5 x3_im_a5 0 3508473312410.142
Cx3_im_a5 x3_im_a5 0 1.0
Gp3_im_re_a5 0 x3_im_a5 x3_re_a5 0 -3508473312410.142
Rp3_im_im_a5 0 x3_im_a5 9.88767760173926e-13
Cx4_re_a5 x4_re_a5 0 1.0
Gx4_re_a5 0 x4_re_a5 p5 0 0.1414213562373095
Fx4_re_a5 0 x4_re_a5 V5 7.0710678118654755
Rp4_re_re_a5 0 x4_re_a5 8.533325723003939e-13
Gp4_re_im_a5 0 x4_re_a5 x4_im_a5 0 2766197540793.715
Cx4_im_a5 x4_im_a5 0 1.0
Gp4_im_re_a5 0 x4_im_a5 x4_re_a5 0 -2766197540793.715
Rp4_im_im_a5 0 x4_im_a5 8.533325723003939e-13
Cx5_re_a5 x5_re_a5 0 1.0
Gx5_re_a5 0 x5_re_a5 p5 0 0.1414213562373095
Fx5_re_a5 0 x5_re_a5 V5 7.0710678118654755
Rp5_re_re_a5 0 x5_re_a5 2.410991705178112e-12
Gp5_re_im_a5 0 x5_re_a5 x5_im_a5 0 2874456996728.0483
Cx5_im_a5 x5_im_a5 0 1.0
Gp5_im_re_a5 0 x5_im_a5 x5_re_a5 0 -2874456996728.0483
Rp5_im_im_a5 0 x5_im_a5 2.410991705178112e-12
Cx6_re_a5 x6_re_a5 0 1.0
Gx6_re_a5 0 x6_re_a5 p5 0 0.1414213562373095
Fx6_re_a5 0 x6_re_a5 V5 7.0710678118654755
Rp6_re_re_a5 0 x6_re_a5 1.6191077353663697e-11
Gp6_re_im_a5 0 x6_re_a5 x6_im_a5 0 2387826528783.5156
Cx6_im_a5 x6_im_a5 0 1.0
Gp6_im_re_a5 0 x6_im_a5 x6_re_a5 0 -2387826528783.5156
Rp6_im_im_a5 0 x6_im_a5 1.6191077353663697e-11
Cx7_re_a5 x7_re_a5 0 1.0
Gx7_re_a5 0 x7_re_a5 p5 0 0.1414213562373095
Fx7_re_a5 0 x7_re_a5 V5 7.0710678118654755
Rp7_re_re_a5 0 x7_re_a5 1.1670965837274465e-12
Gp7_re_im_a5 0 x7_re_a5 x7_im_a5 0 590648106330.5088
Cx7_im_a5 x7_im_a5 0 1.0
Gp7_im_re_a5 0 x7_im_a5 x7_re_a5 0 -590648106330.5088
Rp7_im_im_a5 0 x7_im_a5 1.1670965837274465e-12
Cx8_a5 x8_a5 0 1.0
Gx8_a5 0 x8_a5 p5 0 0.07071067811865475
Fx8_a5 0 x8_a5 V5 3.5355339059327378
Rp8_a5 0 x8_a5 1.057099515142882e-12
Cx9_re_a5 x9_re_a5 0 1.0
Gx9_re_a5 0 x9_re_a5 p5 0 0.1414213562373095
Fx9_re_a5 0 x9_re_a5 V5 7.0710678118654755
Rp9_re_re_a5 0 x9_re_a5 1.5534303609826191e-12
Gp9_re_im_a5 0 x9_re_a5 x9_im_a5 0 455649394468.80255
Cx9_im_a5 x9_im_a5 0 1.0
Gp9_im_re_a5 0 x9_im_a5 x9_re_a5 0 -455649394468.80255
Rp9_im_im_a5 0 x9_im_a5 1.5534303609826191e-12
Cx10_a5 x10_a5 0 1.0
Gx10_a5 0 x10_a5 p5 0 0.07071067811865475
Fx10_a5 0 x10_a5 V5 3.5355339059327378
Rp10_a5 0 x10_a5 5.21381713713202e-12
Cx11_re_a5 x11_re_a5 0 1.0
Gx11_re_a5 0 x11_re_a5 p5 0 0.1414213562373095
Fx11_re_a5 0 x11_re_a5 V5 7.0710678118654755
Rp11_re_re_a5 0 x11_re_a5 1.673721870740383e-11
Gp11_re_im_a5 0 x11_re_a5 x11_im_a5 0 51505589949.64772
Cx11_im_a5 x11_im_a5 0 1.0
Gp11_im_re_a5 0 x11_im_a5 x11_re_a5 0 -51505589949.64772
Rp11_im_im_a5 0 x11_im_a5 1.673721870740383e-11
Cx12_re_a5 x12_re_a5 0 1.0
Gx12_re_a5 0 x12_re_a5 p5 0 0.1414213562373095
Fx12_re_a5 0 x12_re_a5 V5 7.0710678118654755
Rp12_re_re_a5 0 x12_re_a5 6.344273526229328e-11
Gp12_re_im_a5 0 x12_re_a5 x12_im_a5 0 6300408112.88573
Cx12_im_a5 x12_im_a5 0 1.0
Gp12_im_re_a5 0 x12_im_a5 x12_re_a5 0 -6300408112.88573
Rp12_im_im_a5 0 x12_im_a5 6.344273526229328e-11
*
* Port network for port 6
V6 p6 s6 0
R6 s6 0 50.0
Gd6_1 0 s6 p1 0 1.3053599760791225e-07
Fd6_1 0 s6 V1 6.526799880395613e-06
Gr1_6_1 0 s6 x1_a1 0 -1678585370675.7656
Gr2_re_6_1 0 s6 x2_re_a1 0 -65162109832.637024
Gr2_im_6_1 0 s6 x2_im_a1 0 -57580975183.96357
Gr3_re_6_1 0 s6 x3_re_a1 0 62194693937.000114
Gr3_im_6_1 0 s6 x3_im_a1 0 145075629707.24564
Gr4_re_6_1 0 s6 x4_re_a1 0 42474176202.80494
Gr4_im_6_1 0 s6 x4_im_a1 0 88125111235.73753
Gr5_re_6_1 0 s6 x5_re_a1 0 -28959641169.071426
Gr5_im_6_1 0 s6 x5_im_a1 0 -251181206.88607925
Gr6_re_6_1 0 s6 x6_re_a1 0 -7463085.550565389
Gr6_im_6_1 0 s6 x6_im_a1 0 -111828263.62951271
Gr7_re_6_1 0 s6 x7_re_a1 0 25368827062.073624
Gr7_im_6_1 0 s6 x7_im_a1 0 26374612273.50434
Gr8_6_1 0 s6 x8_a1 0 -53522205499.00734
Gr9_re_6_1 0 s6 x9_re_a1 0 130027854838.61208
Gr9_im_6_1 0 s6 x9_im_a1 0 -857550102.4261804
Gr10_6_1 0 s6 x10_a1 0 7527111261.867892
Gr11_re_6_1 0 s6 x11_re_a1 0 -755585307.6352203
Gr11_im_6_1 0 s6 x11_im_a1 0 -276375125.31455094
Gr12_re_6_1 0 s6 x12_re_a1 0 -109310979.17598066
Gr12_im_6_1 0 s6 x12_im_a1 0 -120463038.02762909
Gd6_2 0 s6 p2 0 3.9229265990332187e-07
Fd6_2 0 s6 V2 1.9614632995166095e-05
Gr1_6_2 0 s6 x1_a2 0 335893581472.7929
Gr2_re_6_2 0 s6 x2_re_a2 0 9763584053.906675
Gr2_im_6_2 0 s6 x2_im_a2 0 14489995538.663918
Gr3_re_6_2 0 s6 x3_re_a2 0 53506128732.045425
Gr3_im_6_2 0 s6 x3_im_a2 0 -109399011350.69809
Gr4_re_6_2 0 s6 x4_re_a2 0 -71810131963.54836
Gr4_im_6_2 0 s6 x4_im_a2 0 122134010430.31175
Gr5_re_6_2 0 s6 x5_re_a2 0 -29206476699.23534
Gr5_im_6_2 0 s6 x5_im_a2 0 1268666358.778228
Gr6_re_6_2 0 s6 x6_re_a2 0 22085054.332509432
Gr6_im_6_2 0 s6 x6_im_a2 0 -282540045.2963751
Gr7_re_6_2 0 s6 x7_re_a2 0 -545152525094.20264
Gr7_im_6_2 0 s6 x7_im_a2 0 -90022677117.40527
Gr8_6_2 0 s6 x8_a2 0 1329538303851.464
Gr9_re_6_2 0 s6 x9_re_a2 0 20605719824.76078
Gr9_im_6_2 0 s6 x9_im_a2 0 435279541560.24274
Gr10_6_2 0 s6 x10_a2 0 -11284032396.771683
Gr11_re_6_2 0 s6 x11_re_a2 0 777365703.3474011
Gr11_im_6_2 0 s6 x11_im_a2 0 125335570.10623173
Gr12_re_6_2 0 s6 x12_re_a2 0 85356349.70714065
Gr12_im_6_2 0 s6 x12_im_a2 0 84988279.61914419
Gd6_3 0 s6 p3 0 -1.929507412958692e-07
Fd6_3 0 s6 V3 -9.64753706479346e-06
Gr1_6_3 0 s6 x1_a3 0 401572335798.4962
Gr2_re_6_3 0 s6 x2_re_a3 0 23035939520.118324
Gr2_im_6_3 0 s6 x2_im_a3 0 -53500285953.11178
Gr3_re_6_3 0 s6 x3_re_a3 0 63023654851.601555
Gr3_im_6_3 0 s6 x3_im_a3 0 150286134655.98212
Gr4_re_6_3 0 s6 x4_re_a3 0 28500359664.569935
Gr4_im_6_3 0 s6 x4_im_a3 0 -287637463924.56726
Gr5_re_6_3 0 s6 x5_re_a3 0 -9506759556.247166
Gr5_im_6_3 0 s6 x5_im_a3 0 22614136727.542255
Gr6_re_6_3 0 s6 x6_re_a3 0 135365545.2663339
Gr6_im_6_3 0 s6 x6_im_a3 0 474158978.2944481
Gr7_re_6_3 0 s6 x7_re_a3 0 1066061032980.3512
Gr7_im_6_3 0 s6 x7_im_a3 0 74659654637.903
Gr8_6_3 0 s6 x8_a3 0 -2314794605270.2236
Gr9_re_6_3 0 s6 x9_re_a3 0 -117704466655.79164
Gr9_im_6_3 0 s6 x9_im_a3 0 -587823402520.8254
Gr10_6_3 0 s6 x10_a3 0 19139646839.932243
Gr11_re_6_3 0 s6 x11_re_a3 0 -1352210472.8732748
Gr11_im_6_3 0 s6 x11_im_a3 0 -255603381.973953
Gr12_re_6_3 0 s6 x12_re_a3 0 -164691426.83218208
Gr12_im_6_3 0 s6 x12_im_a3 0 -174336148.74997374
Gd6_4 0 s6 p4 0 3.4458404744395344e-08
Fd6_4 0 s6 V4 1.7229202372197672e-06
Gr1_6_4 0 s6 x1_a4 0 396017401297.081
Gr2_re_6_4 0 s6 x2_re_a4 0 23272078105.22187
Gr2_im_6_4 0 s6 x2_im_a4 0 -52960058218.807495
Gr3_re_6_4 0 s6 x3_re_a4 0 63338345342.24246
Gr3_im_6_4 0 s6 x3_im_a4 0 150082878458.73138
Gr4_re_6_4 0 s6 x4_re_a4 0 28522591350.40483
Gr4_im_6_4 0 s6 x4_im_a4 0 -287085178021.92175
Gr5_re_6_4 0 s6 x5_re_a4 0 -9533882764.326443
Gr5_im_6_4 0 s6 x5_im_a4 0 22553908085.32822
Gr6_re_6_4 0 s6 x6_re_a4 0 135902480.04315397
Gr6_im_6_4 0 s6 x6_im_a4 0 473455279.87362915
Gr7_re_6_4 0 s6 x7_re_a4 0 1061357009242.254
Gr7_im_6_4 0 s6 x7_im_a4 0 74630460182.02293
Gr8_6_4 0 s6 x8_a4 0 -2304204591066.6733
Gr9_re_6_4 0 s6 x9_re_a4 0 -117072665613.6382
Gr9_im_6_4 0 s6 x9_im_a4 0 -585152515814.274
Gr10_6_4 0 s6 x10_a4 0 19036342259.263634
Gr11_re_6_4 0 s6 x11_re_a4 0 -1343632341.5292592
Gr11_im_6_4 0 s6 x11_im_a4 0 -253141322.45594
Gr12_re_6_4 0 s6 x12_re_a4 0 -163541945.62582102
Gr12_im_6_4 0 s6 x12_im_a4 0 -173029966.61876333
Gd6_5 0 s6 p5 0 -4.439799418687329e-07
Fd6_5 0 s6 V5 -2.2198997093436645e-05
Gr1_6_5 0 s6 x1_a5 0 1000225149358.6323
Gr2_re_6_5 0 s6 x2_re_a5 0 -6262048881.276426
Gr2_im_6_5 0 s6 x2_im_a5 0 -50975139824.22364
Gr3_re_6_5 0 s6 x3_re_a5 0 144899393351.1236
Gr3_im_6_5 0 s6 x3_im_a5 0 47757488570.464645
Gr4_re_6_5 0 s6 x4_re_a5 0 -40273297338.574356
Gr4_im_6_5 0 s6 x4_im_a5 0 -112722791676.26256
Gr5_re_6_5 0 s6 x5_re_a5 0 -17771502083.328205
Gr5_im_6_5 0 s6 x5_im_a5 0 8091936105.159853
Gr6_re_6_5 0 s6 x6_re_a5 0 133822009.21946716
Gr6_im_6_5 0 s6 x6_im_a5 0 121490735.68511905
Gr7_re_6_5 0 s6 x7_re_a5 0 350754211044.1963
Gr7_im_6_5 0 s6 x7_im_a5 0 -31564995345.425785
Gr8_6_5 0 s6 x8_a5 0 -903800470428.4075
Gr9_re_6_5 0 s6 x9_re_a5 0 -37854581207.404686
Gr9_im_6_5 0 s6 x9_im_a5 0 -277651833226.58716
Gr10_6_5 0 s6 x10_a5 0 3963041682.7644377
Gr11_re_6_5 0 s6 x11_re_a5 0 -177769771.3362959
Gr11_im_6_5 0 s6 x11_im_a5 0 9967116.05601396
Gr12_re_6_5 0 s6 x12_re_a5 0 -18102936.98258531
Gr12_im_6_5 0 s6 x12_im_a5 0 -35965396.52959981
Gd6_6 0 s6 p6 0 -2.163863787596476e-08
Fd6_6 0 s6 V6 -1.081931893798238e-06
Gr1_6_6 0 s6 x1_a6 0 -651346043321.4056
Gr2_re_6_6 0 s6 x2_re_a6 0 141986225301.79037
Gr2_im_6_6 0 s6 x2_im_a6 0 14502314549.798237
Gr3_re_6_6 0 s6 x3_re_a6 0 237098810145.91107
Gr3_im_6_6 0 s6 x3_im_a6 0 -122868494538.54494
Gr4_re_6_6 0 s6 x4_re_a6 0 -112857274507.39113
Gr4_im_6_6 0 s6 x4_im_a6 0 -362340975172.51495
Gr5_re_6_6 0 s6 x5_re_a6 0 -8319932768.87966
Gr5_im_6_6 0 s6 x5_im_a6 0 12646282657.854927
Gr6_re_6_6 0 s6 x6_re_a6 0 192831635.30536342
Gr6_im_6_6 0 s6 x6_im_a6 0 480378820.59866595
Gr7_re_6_6 0 s6 x7_re_a6 0 1080288646319.5293
Gr7_im_6_6 0 s6 x7_im_a6 0 69794408034.43442
Gr8_6_6 0 s6 x8_a6 0 -2354129085619.261
Gr9_re_6_6 0 s6 x9_re_a6 0 -249087346652.24725
Gr9_im_6_6 0 s6 x9_im_a6 0 -646446502028.4325
Gr10_6_6 0 s6 x10_a6 0 16447602200.687138
Gr11_re_6_6 0 s6 x11_re_a6 0 -1133875651.5413582
Gr11_im_6_6 0 s6 x11_im_a6 0 -178634918.78418827
Gr12_re_6_6 0 s6 x12_re_a6 0 -134779761.4107783
Gr12_im_6_6 0 s6 x12_im_a6 0 -133369686.80325454
Gd6_7 0 s6 p7 0 6.76419214691304e-07
Fd6_7 0 s6 V7 3.38209607345652e-05
Gr1_6_7 0 s6 x1_a7 0 904294096863.4833
Gr2_re_6_7 0 s6 x2_re_a7 0 -6139679326.888406
Gr2_im_6_7 0 s6 x2_im_a7 0 4688159163.638296
Gr3_re_6_7 0 s6 x3_re_a7 0 -123449335372.46939
Gr3_im_6_7 0 s6 x3_im_a7 0 -100082715337.56285
Gr4_re_6_7 0 s6 x4_re_a7 0 -26909736993.17391
Gr4_im_6_7 0 s6 x4_im_a7 0 113603804103.63303
Gr5_re_6_7 0 s6 x5_re_a7 0 -34209174807.585236
Gr5_im_6_7 0 s6 x5_im_a7 0 -2326986277.650351
Gr6_re_6_7 0 s6 x6_re_a7 0 -63936701.26357027
Gr6_im_6_7 0 s6 x6_im_a7 0 -222344810.27584982
Gr7_re_6_7 0 s6 x7_re_a7 0 -398086018300.66394
Gr7_im_6_7 0 s6 x7_im_a7 0 20808837521.14892
Gr8_6_7 0 s6 x8_a7 0 861352943703.0503
Gr9_re_6_7 0 s6 x9_re_a7 0 62817059311.37091
Gr9_im_6_7 0 s6 x9_im_a7 0 185199755197.4651
Gr10_6_7 0 s6 x10_a7 0 -3201051926.1419735
Gr11_re_6_7 0 s6 x11_re_a7 0 108499432.1523799
Gr11_im_6_7 0 s6 x11_im_a7 0 -55933094.10733206
Gr12_re_6_7 0 s6 x12_re_a7 0 2799682.723794469
Gr12_im_6_7 0 s6 x12_im_a7 0 -3046766.825959236
Gd6_8 0 s6 p8 0 5.922039790950961e-07
Fd6_8 0 s6 V8 2.9610198954754807e-05
Gr1_6_8 0 s6 x1_a8 0 907840398811.4209
Gr2_re_6_8 0 s6 x2_re_a8 0 -6399822925.57362
Gr2_im_6_8 0 s6 x2_im_a8 0 4233685016.6205587
Gr3_re_6_8 0 s6 x3_re_a8 0 -123823492868.99857
Gr3_im_6_8 0 s6 x3_im_a8 0 -100457202617.1696
Gr4_re_6_8 0 s6 x4_re_a8 0 -27327289918.134502
Gr4_im_6_8 0 s6 x4_im_a8 0 114289196134.14188
Gr5_re_6_8 0 s6 x5_re_a8 0 -34223672708.850735
Gr5_im_6_8 0 s6 x5_im_a8 0 -2370341141.3806252
Gr6_re_6_8 0 s6 x6_re_a8 0 -63439211.71311897
Gr6_im_6_8 0 s6 x6_im_a8 0 -221875988.74502912
Gr7_re_6_8 0 s6 x7_re_a8 0 -399756006520.51
Gr7_im_6_8 0 s6 x7_im_a8 0 20290499546.614933
Gr8_6_8 0 s6 x8_a8 0 864595201588.8324
Gr9_re_6_8 0 s6 x9_re_a8 0 62913431209.75916
Gr9_im_6_8 0 s6 x9_im_a8 0 186244914899.91418
Gr10_6_8 0 s6 x10_a8 0 -3237482414.3025055
Gr11_re_6_8 0 s6 x11_re_a8 0 111093520.0393473
Gr11_im_6_8 0 s6 x11_im_a8 0 -54839768.86700258
Gr12_re_6_8 0 s6 x12_re_a8 0 3321941.936380606
Gr12_im_6_8 0 s6 x12_im_a8 0 -2393240.5684865634
*
* State networks driven by port 6
Cx1_a6 x1_a6 0 1.0
Gx1_a6 0 x1_a6 p6 0 0.07071067811865475
Fx1_a6 0 x1_a6 V6 3.5355339059327378
Rp1_a6 0 x1_a6 9.217407145044509e-14
Cx2_re_a6 x2_re_a6 0 1.0
Gx2_re_a6 0 x2_re_a6 p6 0 0.1414213562373095
Fx2_re_a6 0 x2_re_a6 V6 7.0710678118654755
Rp2_re_re_a6 0 x2_re_a6 1.0786132166118383e-12
Gp2_re_im_a6 0 x2_re_a6 x2_im_a6 0 5111233610923.186
Cx2_im_a6 x2_im_a6 0 1.0
Gp2_im_re_a6 0 x2_im_a6 x2_re_a6 0 -5111233610923.186
Rp2_im_im_a6 0 x2_im_a6 1.0786132166118383e-12
Cx3_re_a6 x3_re_a6 0 1.0
Gx3_re_a6 0 x3_re_a6 p6 0 0.1414213562373095
Fx3_re_a6 0 x3_re_a6 V6 7.0710678118654755
Rp3_re_re_a6 0 x3_re_a6 9.88767760173926e-13
Gp3_re_im_a6 0 x3_re_a6 x3_im_a6 0 3508473312410.142
Cx3_im_a6 x3_im_a6 0 1.0
Gp3_im_re_a6 0 x3_im_a6 x3_re_a6 0 -3508473312410.142
Rp3_im_im_a6 0 x3_im_a6 9.88767760173926e-13
Cx4_re_a6 x4_re_a6 0 1.0
Gx4_re_a6 0 x4_re_a6 p6 0 0.1414213562373095
Fx4_re_a6 0 x4_re_a6 V6 7.0710678118654755
Rp4_re_re_a6 0 x4_re_a6 8.533325723003939e-13
Gp4_re_im_a6 0 x4_re_a6 x4_im_a6 0 2766197540793.715
Cx4_im_a6 x4_im_a6 0 1.0
Gp4_im_re_a6 0 x4_im_a6 x4_re_a6 0 -2766197540793.715
Rp4_im_im_a6 0 x4_im_a6 8.533325723003939e-13
Cx5_re_a6 x5_re_a6 0 1.0
Gx5_re_a6 0 x5_re_a6 p6 0 0.1414213562373095
Fx5_re_a6 0 x5_re_a6 V6 7.0710678118654755
Rp5_re_re_a6 0 x5_re_a6 2.410991705178112e-12
Gp5_re_im_a6 0 x5_re_a6 x5_im_a6 0 2874456996728.0483
Cx5_im_a6 x5_im_a6 0 1.0
Gp5_im_re_a6 0 x5_im_a6 x5_re_a6 0 -2874456996728.0483
Rp5_im_im_a6 0 x5_im_a6 2.410991705178112e-12
Cx6_re_a6 x6_re_a6 0 1.0
Gx6_re_a6 0 x6_re_a6 p6 0 0.1414213562373095
Fx6_re_a6 0 x6_re_a6 V6 7.0710678118654755
Rp6_re_re_a6 0 x6_re_a6 1.6191077353663697e-11
Gp6_re_im_a6 0 x6_re_a6 x6_im_a6 0 2387826528783.5156
Cx6_im_a6 x6_im_a6 0 1.0
Gp6_im_re_a6 0 x6_im_a6 x6_re_a6 0 -2387826528783.5156
Rp6_im_im_a6 0 x6_im_a6 1.6191077353663697e-11
Cx7_re_a6 x7_re_a6 0 1.0
Gx7_re_a6 0 x7_re_a6 p6 0 0.1414213562373095
Fx7_re_a6 0 x7_re_a6 V6 7.0710678118654755
Rp7_re_re_a6 0 x7_re_a6 1.1670965837274465e-12
Gp7_re_im_a6 0 x7_re_a6 x7_im_a6 0 590648106330.5088
Cx7_im_a6 x7_im_a6 0 1.0
Gp7_im_re_a6 0 x7_im_a6 x7_re_a6 0 -590648106330.5088
Rp7_im_im_a6 0 x7_im_a6 1.1670965837274465e-12
Cx8_a6 x8_a6 0 1.0
Gx8_a6 0 x8_a6 p6 0 0.07071067811865475
Fx8_a6 0 x8_a6 V6 3.5355339059327378
Rp8_a6 0 x8_a6 1.057099515142882e-12
Cx9_re_a6 x9_re_a6 0 1.0
Gx9_re_a6 0 x9_re_a6 p6 0 0.1414213562373095
Fx9_re_a6 0 x9_re_a6 V6 7.0710678118654755
Rp9_re_re_a6 0 x9_re_a6 1.5534303609826191e-12
Gp9_re_im_a6 0 x9_re_a6 x9_im_a6 0 455649394468.80255
Cx9_im_a6 x9_im_a6 0 1.0
Gp9_im_re_a6 0 x9_im_a6 x9_re_a6 0 -455649394468.80255
Rp9_im_im_a6 0 x9_im_a6 1.5534303609826191e-12
Cx10_a6 x10_a6 0 1.0
Gx10_a6 0 x10_a6 p6 0 0.07071067811865475
Fx10_a6 0 x10_a6 V6 3.5355339059327378
Rp10_a6 0 x10_a6 5.21381713713202e-12
Cx11_re_a6 x11_re_a6 0 1.0
Gx11_re_a6 0 x11_re_a6 p6 0 0.1414213562373095
Fx11_re_a6 0 x11_re_a6 V6 7.0710678118654755
Rp11_re_re_a6 0 x11_re_a6 1.673721870740383e-11
Gp11_re_im_a6 0 x11_re_a6 x11_im_a6 0 51505589949.64772
Cx11_im_a6 x11_im_a6 0 1.0
Gp11_im_re_a6 0 x11_im_a6 x11_re_a6 0 -51505589949.64772
Rp11_im_im_a6 0 x11_im_a6 1.673721870740383e-11
Cx12_re_a6 x12_re_a6 0 1.0
Gx12_re_a6 0 x12_re_a6 p6 0 0.1414213562373095
Fx12_re_a6 0 x12_re_a6 V6 7.0710678118654755
Rp12_re_re_a6 0 x12_re_a6 6.344273526229328e-11
Gp12_re_im_a6 0 x12_re_a6 x12_im_a6 0 6300408112.88573
Cx12_im_a6 x12_im_a6 0 1.0
Gp12_im_re_a6 0 x12_im_a6 x12_re_a6 0 -6300408112.88573
Rp12_im_im_a6 0 x12_im_a6 6.344273526229328e-11
*
* Port network for port 7
V7 p7 s7 0
R7 s7 0 50.0
Gd7_1 0 s7 p1 0 -6.817449292422819e-08
Fd7_1 0 s7 V1 -3.4087246462114096e-06
Gr1_7_1 0 s7 x1_a1 0 439002358279.4953
Gr2_re_7_1 0 s7 x2_re_a1 0 33706328335.569466
Gr2_im_7_1 0 s7 x2_im_a1 0 -72025653991.0812
Gr3_re_7_1 0 s7 x3_re_a1 0 52600271271.21423
Gr3_im_7_1 0 s7 x3_im_a1 0 110791364483.4089
Gr4_re_7_1 0 s7 x4_re_a1 0 -4083404121.450431
Gr4_im_7_1 0 s7 x4_im_a1 0 -238332091681.60742
Gr5_re_7_1 0 s7 x5_re_a1 0 -14166578149.105116
Gr5_im_7_1 0 s7 x5_im_a1 0 14580804801.088905
Gr6_re_7_1 0 s7 x6_re_a1 0 152677351.88337994
Gr6_im_7_1 0 s7 x6_im_a1 0 360978072.3257893
Gr7_re_7_1 0 s7 x7_re_a1 0 852987401088.9387
Gr7_im_7_1 0 s7 x7_im_a1 0 27918467976.4119
Gr8_7_1 0 s7 x8_a1 0 -1870319318857.4277
Gr9_re_7_1 0 s7 x9_re_a1 0 -104089461288.10912
Gr9_im_7_1 0 s7 x9_im_a1 0 -456378172120.2564
Gr10_7_1 0 s7 x10_a1 0 14577711727.467377
Gr11_re_7_1 0 s7 x11_re_a1 0 -1022470605.94415
Gr11_im_7_1 0 s7 x11_im_a1 0 -197536909.30528155
Gr12_re_7_1 0 s7 x12_re_a1 0 -125536528.28693281
Gr12_im_7_1 0 s7 x12_im_a1 0 -134137571.39009938
Gd7_2 0 s7 p2 0 -2.9154646683304116e-07
Fd7_2 0 s7 V2 -1.4577323341652057e-05
Gr1_7_2 0 s7 x1_a2 0 1715651719756.7292
Gr2_re_7_2 0 s7 x2_re_a2 0 -10319954530.641535
Gr2_im_7_2 0 s7 x2_im_a2 0 -25611843138.37955
Gr3_re_7_2 0 s7 x3_re_a2 0 29970805345.15813
Gr3_im_7_2 0 s7 x3_im_a2 0 63340540595.76196
Gr4_re_7_2 0 s7 x4_re_a2 0 -14067925052.355154
Gr4_im_7_2 0 s7 x4_im_a2 0 -212751216183.98288
Gr5_re_7_2 0 s7 x5_re_a2 0 -11207265758.055225
Gr5_im_7_2 0 s7 x5_im_a2 0 21997767797.22298
Gr6_re_7_2 0 s7 x6_re_a2 0 131358907.42749132
Gr6_im_7_2 0 s7 x6_im_a2 0 304697396.68605775
Gr7_re_7_2 0 s7 x7_re_a2 0 761431669303.9952
Gr7_im_7_2 0 s7 x7_im_a2 0 59568122202.32586
Gr8_7_2 0 s7 x8_a2 0 -1709849940827.054
Gr9_re_7_2 0 s7 x9_re_a2 0 -113090913103.93675
Gr9_im_7_2 0 s7 x9_im_a2 0 -411080076363.4307
Gr10_7_2 0 s7 x10_a2 0 15260759475.256172
Gr11_re_7_2 0 s7 x11_re_a2 0 -1145516434.244315
Gr11_im_7_2 0 s7 x11_im_a2 0 -230858599.3103314
Gr12_re_7_2 0 s7 x12_re_a2 0 -142755848.22030404
Gr12_im_7_2 0 s7 x12_im_a2 0 -155808266.37231722
Gd7_3 0 s7 p3 0 -1.0528672625026827e-06
Fd7_3 0 s7 V3 -5.264336312513413e-05
Gr1_7_3 0 s7 x1_a3 0 -1232476166082.8733
Gr2_re_7_3 0 s7 x2_re_a3 0 -18659851561.266865
Gr2_im_7_3 0 s7 x2_im_a3 0 -6347494372.038748
Gr3_re_7_3 0 s7 x3_re_a3 0 -249651047083.10922
Gr3_im_7_3 0 s7 x3_im_a3 0 -203962638633.62854
Gr4_re_7_3 0 s7 x4_re_a3 0 323823158138.03864
Gr4_im_7_3 0 s7 x4_im_a3 0 576294176336.8435
Gr5_re_7_3 0 s7 x5_re_a3 0 -68200348852.08839
Gr5_im_7_3 0 s7 x5_im_a3 0 -9305933317.30456
Gr6_re_7_3 0 s7 x6_re_a3 0 -2665432324.979052
Gr6_im_7_3 0 s7 x6_im_a3 0 -1944953495.1698005
Gr7_re_7_3 0 s7 x7_re_a3 0 -2773660031926.2695
Gr7_im_7_3 0 s7 x7_im_a3 0 -102121774431.24179
Gr8_7_3 0 s7 x8_a3 0 5551442275121.394
Gr9_re_7_3 0 s7 x9_re_a3 0 440227220755.87506
Gr9_im_7_3 0 s7 x9_im_a3 0 1398521352541.2976
Gr10_7_3 0 s7 x10_a3 0 -41668081800.976814
Gr11_re_7_3 0 s7 x11_re_a3 0 2993855196.332515
Gr11_im_7_3 0 s7 x11_im_a3 0 512032607.38548297
Gr12_re_7_3 0 s7 x12_re_a3 0 361839102.8125711
Gr12_im_7_3 0 s7 x12_im_a3 0 357117044.61289686
Gd7_4 0 s7 p4 0 1.961073330092192e-06
Fd7_4 0 s7 V4 9.80536665046096e-05
Gr1_7_4 0 s7 x1_a4 0 853800103805.6459
Gr2_re_7_4 0 s7 x2_re_a4 0 -48722414413.2979
Gr2_im_7_4 0 s7 x2_im_a4 0 -19754668966.63551
Gr3_re_7_4 0 s7 x3_re_a4 0 260547980995.64612
Gr3_im_7_4 0 s7 x3_im_a4 0 86581748697.53679
Gr4_re_7_4 0 s7 x4_re_a4 0 -326108435340.2863
Gr4_im_7_4 0 s7 x4_im_a4 0 -250763631872.23517
Gr5_re_7_4 0 s7 x5_re_a4 0 -2345402011.7422123
Gr5_im_7_4 0 s7 x5_im_a4 0 18732789803.716778
Gr6_re_7_4 0 s7 x6_re_a4 0 2507864266.024276
Gr6_im_7_4 0 s7 x6_im_a4 0 1422114992.5065064
Gr7_re_7_4 0 s7 x7_re_a4 0 1620233919027.9746
Gr7_im_7_4 0 s7 x7_im_a4 0 47507000575.8741
Gr8_7_4 0 s7 x8_a4 0 -3096119334836.935
Gr9_re_7_4 0 s7 x9_re_a4 0 -248405030211.7995
Gr9_im_7_4 0 s7 x9_im_a4 0 -727070321105.5787
Gr10_7_4 0 s7 x10_a4 0 23286652567.63194
Gr11_re_7_4 0 s7 x11_re_a4 0 -1785847657.0845428
Gr11_im_7_4 0 s7 x11_im_a4 0 -369998650.2142783
Gr12_re_7_4 0 s7 x12_re_a4 0 -228000178.73278278
Gr12_im_7_4 0 s7 x12_im_a4 0 -222371529.92427486
Gd7_5 0 s7 p5 0 7.231157521347952e-07
Fd7_5 0 s7 V5 3.6155787606739764e-05
Gr1_7_5 0 s7 x1_a5 0 136093079652.39485
Gr2_re_7_5 0 s7 x2_re_a5 0 -14743577399.311888
Gr2_im_7_5 0 s7 x2_im_a5 0 4240614462.151095
Gr3_re_7_5 0 s7 x3_re_a5 0 -131212884209.55202
Gr3_im_7_5 0 s7 x3_im_a5 0 -49819326959.09433
Gr4_re_7_5 0 s7 x4_re_a5 0 -2305700753.713691
Gr4_im_7_5 0 s7 x4_im_a5 0 132562981944.0
Gr5_re_7_5 0 s7 x5_re_a5 0 -34377373310.124016
Gr5_im_7_5 0 s7 x5_im_a5 0 3000624980.3137884
Gr6_re_7_5 0 s7 x6_re_a5 0 -57379665.077139825
Gr6_im_7_5 0 s7 x6_im_a5 0 -214294663.4847646
Gr7_re_7_5 0 s7 x7_re_a5 0 -492941004208.2713
Gr7_im_7_5 0 s7 x7_im_a5 0 -56051628171.91346
Gr8_7_5 0 s7 x8_a5 0 1127893488849.536
Gr9_re_7_5 0 s7 x9_re_a5 0 75029267740.50722
Gr9_im_7_5 0 s7 x9_im_a5 0 262692469019.621
Gr10_7_5 0 s7 x10_a5 0 -9931322422.330935
Gr11_re_7_5 0 s7 x11_re_a5 0 751343304.5868338
Gr11_im_7_5 0 s7 x11_im_a5 0 132828139.46085604
Gr12_re_7_5 0 s7 x12_re_a5 0 92224529.10510926
Gr12_im_7_5 0 s7 x12_im_a5 0 98224690.2997444
Gd7_6 0 s7 p6 0 6.76419214691304e-07
Fd7_6 0 s7 V6 3.38209607345652e-05
Gr1_7_6 0 s7 x1_a6 0 904294096863.4933
Gr2_re_7_6 0 s7 x2_re_a6 0 -6139679326.889028
Gr2_im_7_6 0 s7 x2_im_a6 0 4688159163.637387
Gr3_re_7_6 0 s7 x3_re_a6 0 -123449335372.46983
Gr3_im_7_6 0 s7 x3_im_a6 0 -100082715337.56448
Gr4_re_7_6 0 s7 x4_re_a6 0 -26909736993.176956
Gr4_im_7_6 0 s7 x4_im_a6 0 113603804103.63504
Gr5_re_7_6 0 s7 x5_re_a6 0 -34209174807.585155
Gr5_im_7_6 0 s7 x5_im_a6 0 -2326986277.65055
Gr6_re_7_6 0 s7 x6_re_a6 0 -63936701.26356365
Gr6_im_7_6 0 s7 x6_im_a6 0 -222344810.2758508
Gr7_re_7_6 0 s7 x7_re_a6 0 -398086018300.6869
Gr7_im_7_6 0 s7 x7_im_a6 0 20808837521.13668
Gr8_7_6 0 s7 x8_a6 0 861352943703.1063
Gr9_re_7_6 0 s7 x9_re_a6 0 62817059311.36774
Gr9_im_7_6 0 s7 x9_im_a6 0 185199755197.4833
Gr10_7_6 0 s7 x10_a6 0 -3201051926.1429086
Gr11_re_7_6 0 s7 x11_re_a6 0 108499432.15247642
Gr11_im_7_6 0 s7 x11_im_a6 0 -55933094.10726947
Gr12_re_7_6 0 s7 x12_re_a6 0 2799682.723808184
Gr12_im_7_6 0 s7 x12_im_a6 0 -3046766.825937875
Gd7_7 0 s7 p7 0 4.288917249328783e-07
Fd7_7 0 s7 V7 2.1444586246643915e-05
Gr1_7_7 0 s7 x1_a7 0 -3420014068542.248
Gr2_re_7_7 0 s7 x2_re_a7 0 236467869699.0527
Gr2_im_7_7 0 s7 x2_im_a7 0 200221459854.74545
Gr3_re_7_7 0 s7 x3_re_a7 0 73145114714.71964
Gr3_im_7_7 0 s7 x3_im_a7 0 -100870469426.21942
Gr4_re_7_7 0 s7 x4_re_a7 0 284206102588.14026
Gr4_im_7_7 0 s7 x4_im_a7 0 72534217274.01527
Gr5_re_7_7 0 s7 x5_re_a7 0 -38576829742.49135
Gr5_im_7_7 0 s7 x5_im_a7 0 731558344.1400799
Gr6_re_7_7 0 s7 x6_re_a7 0 -2103240832.2785635
Gr6_im_7_7 0 s7 x6_im_a7 0 -2121065386.9611793
Gr7_re_7_7 0 s7 x7_re_a7 0 -568729621058.7837
Gr7_im_7_7 0 s7 x7_im_a7 0 86037068300.24345
Gr8_7_7 0 s7 x8_a7 0 1555951925041.141
Gr9_re_7_7 0 s7 x9_re_a7 0 95654813867.06497
Gr9_im_7_7 0 s7 x9_im_a7 0 443098607046.45624
Gr10_7_7 0 s7 x10_a7 0 -14821182706.452047
Gr11_re_7_7 0 s7 x11_re_a7 0 981769111.7233065
Gr11_im_7_7 0 s7 x11_im_a7 0 206506903.86258596
Gr12_re_7_7 0 s7 x12_re_a7 0 115713246.38997877
Gr12_im_7_7 0 s7 x12_im_a7 0 139371031.08364892
Gd7_8 0 s7 p8 0 -1.4327383218148972e-06
Fd7_8 0 s7 V8 -7.163691609074486e-05
Gr1_7_8 0 s7 x1_a8 0 2849986710577.8926
Gr2_re_7_8 0 s7 x2_re_a8 0 -157550573699.4053
Gr2_im_7_8 0 s7 x2_im_a8 0 -211753092762.6254
Gr3_re_7_8 0 s7 x3_re_a8 0 288542937568.03156
Gr3_im_7_8 0 s7 x3_im_a8 0 173876242900.4594
Gr4_re_7_8 0 s7 x4_re_a8 0 -327531159969.19806
Gr4_im_7_8 0 s7 x4_im_a8 0 -495054617108.3962
Gr5_re_7_8 0 s7 x5_re_a8 0 8506062105.322279
Gr5_im_7_8 0 s7 x5_im_a8 0 29302319621.366657
Gr6_re_7_8 0 s7 x6_re_a8 0 2354601123.218297
Gr6_im_7_8 0 s7 x6_im_a8 0 2736320172.5843225
Gr7_re_7_8 0 s7 x7_re_a8 0 1957974022793.8167
Gr7_im_7_8 0 s7 x7_im_a8 0 4491463257.24129
Gr8_7_8 0 s7 x8_a8 0 -4513995478805.796
Gr9_re_7_8 0 s7 x9_re_a8 0 -306567863404.9568
Gr9_im_7_8 0 s7 x9_im_a8 0 -1251206100994.1882
Gr10_7_8 0 s7 x10_a8 0 38933913381.7977
Gr11_re_7_8 0 s7 x11_re_a8 0 -2708047426.663944
Gr11_im_7_8 0 s7 x11_im_a8 0 -519493089.70665944
Gr12_re_7_8 0 s7 x12_re_a8 0 -331077268.38927084
Gr12_im_7_8 0 s7 x12_im_a8 0 -376251628.9768387
*
* State networks driven by port 7
Cx1_a7 x1_a7 0 1.0
Gx1_a7 0 x1_a7 p7 0 0.07071067811865475
Fx1_a7 0 x1_a7 V7 3.5355339059327378
Rp1_a7 0 x1_a7 9.217407145044509e-14
Cx2_re_a7 x2_re_a7 0 1.0
Gx2_re_a7 0 x2_re_a7 p7 0 0.1414213562373095
Fx2_re_a7 0 x2_re_a7 V7 7.0710678118654755
Rp2_re_re_a7 0 x2_re_a7 1.0786132166118383e-12
Gp2_re_im_a7 0 x2_re_a7 x2_im_a7 0 5111233610923.186
Cx2_im_a7 x2_im_a7 0 1.0
Gp2_im_re_a7 0 x2_im_a7 x2_re_a7 0 -5111233610923.186
Rp2_im_im_a7 0 x2_im_a7 1.0786132166118383e-12
Cx3_re_a7 x3_re_a7 0 1.0
Gx3_re_a7 0 x3_re_a7 p7 0 0.1414213562373095
Fx3_re_a7 0 x3_re_a7 V7 7.0710678118654755
Rp3_re_re_a7 0 x3_re_a7 9.88767760173926e-13
Gp3_re_im_a7 0 x3_re_a7 x3_im_a7 0 3508473312410.142
Cx3_im_a7 x3_im_a7 0 1.0
Gp3_im_re_a7 0 x3_im_a7 x3_re_a7 0 -3508473312410.142
Rp3_im_im_a7 0 x3_im_a7 9.88767760173926e-13
Cx4_re_a7 x4_re_a7 0 1.0
Gx4_re_a7 0 x4_re_a7 p7 0 0.1414213562373095
Fx4_re_a7 0 x4_re_a7 V7 7.0710678118654755
Rp4_re_re_a7 0 x4_re_a7 8.533325723003939e-13
Gp4_re_im_a7 0 x4_re_a7 x4_im_a7 0 2766197540793.715
Cx4_im_a7 x4_im_a7 0 1.0
Gp4_im_re_a7 0 x4_im_a7 x4_re_a7 0 -2766197540793.715
Rp4_im_im_a7 0 x4_im_a7 8.533325723003939e-13
Cx5_re_a7 x5_re_a7 0 1.0
Gx5_re_a7 0 x5_re_a7 p7 0 0.1414213562373095
Fx5_re_a7 0 x5_re_a7 V7 7.0710678118654755
Rp5_re_re_a7 0 x5_re_a7 2.410991705178112e-12
Gp5_re_im_a7 0 x5_re_a7 x5_im_a7 0 2874456996728.0483
Cx5_im_a7 x5_im_a7 0 1.0
Gp5_im_re_a7 0 x5_im_a7 x5_re_a7 0 -2874456996728.0483
Rp5_im_im_a7 0 x5_im_a7 2.410991705178112e-12
Cx6_re_a7 x6_re_a7 0 1.0
Gx6_re_a7 0 x6_re_a7 p7 0 0.1414213562373095
Fx6_re_a7 0 x6_re_a7 V7 7.0710678118654755
Rp6_re_re_a7 0 x6_re_a7 1.6191077353663697e-11
Gp6_re_im_a7 0 x6_re_a7 x6_im_a7 0 2387826528783.5156
Cx6_im_a7 x6_im_a7 0 1.0
Gp6_im_re_a7 0 x6_im_a7 x6_re_a7 0 -2387826528783.5156
Rp6_im_im_a7 0 x6_im_a7 1.6191077353663697e-11
Cx7_re_a7 x7_re_a7 0 1.0
Gx7_re_a7 0 x7_re_a7 p7 0 0.1414213562373095
Fx7_re_a7 0 x7_re_a7 V7 7.0710678118654755
Rp7_re_re_a7 0 x7_re_a7 1.1670965837274465e-12
Gp7_re_im_a7 0 x7_re_a7 x7_im_a7 0 590648106330.5088
Cx7_im_a7 x7_im_a7 0 1.0
Gp7_im_re_a7 0 x7_im_a7 x7_re_a7 0 -590648106330.5088
Rp7_im_im_a7 0 x7_im_a7 1.1670965837274465e-12
Cx8_a7 x8_a7 0 1.0
Gx8_a7 0 x8_a7 p7 0 0.07071067811865475
Fx8_a7 0 x8_a7 V7 3.5355339059327378
Rp8_a7 0 x8_a7 1.057099515142882e-12
Cx9_re_a7 x9_re_a7 0 1.0
Gx9_re_a7 0 x9_re_a7 p7 0 0.1414213562373095
Fx9_re_a7 0 x9_re_a7 V7 7.0710678118654755
Rp9_re_re_a7 0 x9_re_a7 1.5534303609826191e-12
Gp9_re_im_a7 0 x9_re_a7 x9_im_a7 0 455649394468.80255
Cx9_im_a7 x9_im_a7 0 1.0
Gp9_im_re_a7 0 x9_im_a7 x9_re_a7 0 -455649394468.80255
Rp9_im_im_a7 0 x9_im_a7 1.5534303609826191e-12
Cx10_a7 x10_a7 0 1.0
Gx10_a7 0 x10_a7 p7 0 0.07071067811865475
Fx10_a7 0 x10_a7 V7 3.5355339059327378
Rp10_a7 0 x10_a7 5.21381713713202e-12
Cx11_re_a7 x11_re_a7 0 1.0
Gx11_re_a7 0 x11_re_a7 p7 0 0.1414213562373095
Fx11_re_a7 0 x11_re_a7 V7 7.0710678118654755
Rp11_re_re_a7 0 x11_re_a7 1.673721870740383e-11
Gp11_re_im_a7 0 x11_re_a7 x11_im_a7 0 51505589949.64772
Cx11_im_a7 x11_im_a7 0 1.0
Gp11_im_re_a7 0 x11_im_a7 x11_re_a7 0 -51505589949.64772
Rp11_im_im_a7 0 x11_im_a7 1.673721870740383e-11
Cx12_re_a7 x12_re_a7 0 1.0
Gx12_re_a7 0 x12_re_a7 p7 0 0.1414213562373095
Fx12_re_a7 0 x12_re_a7 V7 7.0710678118654755
Rp12_re_re_a7 0 x12_re_a7 6.344273526229328e-11
Gp12_re_im_a7 0 x12_re_a7 x12_im_a7 0 6300408112.88573
Cx12_im_a7 x12_im_a7 0 1.0
Gp12_im_re_a7 0 x12_im_a7 x12_re_a7 0 -6300408112.88573
Rp12_im_im_a7 0 x12_im_a7 6.344273526229328e-11
*
* Port network for port 8
V8 p8 s8 0
R8 s8 0 50.0
Gd8_1 0 s8 p1 0 -3.0196381731590476e-07
Fd8_1 0 s8 V1 -1.5098190865795239e-05
Gr1_8_1 0 s8 x1_a1 0 434242624746.4775
Gr2_re_8_1 0 s8 x2_re_a1 0 34462886239.39192
Gr2_im_8_1 0 s8 x2_im_a1 0 -70844954620.4803
Gr3_re_8_1 0 s8 x3_re_a1 0 54404091186.43486
Gr3_im_8_1 0 s8 x3_im_a1 0 111398350069.14545
Gr4_re_8_1 0 s8 x4_re_a1 0 -4290772832.2398276
Gr4_im_8_1 0 s8 x4_im_a1 0 -240616421259.61832
Gr5_re_8_1 0 s8 x5_re_a1 0 -14025592591.127796
Gr5_im_8_1 0 s8 x5_im_a1 0 14607932753.897892
Gr6_re_8_1 0 s8 x6_re_a1 0 153107346.58557364
Gr6_im_8_1 0 s8 x6_im_a1 0 364268015.3891103
Gr7_re_8_1 0 s8 x7_re_a1 0 858905789200.4014
Gr7_im_8_1 0 s8 x7_im_a1 0 28232399641.96658
Gr8_8_1 0 s8 x8_a1 0 -1882297474371.0083
Gr9_re_8_1 0 s8 x9_re_a1 0 -105016036278.92407
Gr9_im_8_1 0 s8 x9_im_a1 0 -459650077559.7849
Gr10_8_1 0 s8 x10_a1 0 14663835173.145979
Gr11_re_8_1 0 s8 x11_re_a1 0 -1027408491.042076
Gr11_im_8_1 0 s8 x11_im_a1 0 -198948508.88047323
Gr12_re_8_1 0 s8 x12_re_a1 0 -126635247.87319292
Gr12_im_8_1 0 s8 x12_im_a1 0 -135545428.97812364
Gd8_2 0 s8 p2 0 1.0254172583176387e-07
Fd8_2 0 s8 V2 5.127086291588194e-06
Gr1_8_2 0 s8 x1_a2 0 1713614174954.0928
Gr2_re_8_2 0 s8 x2_re_a2 0 -9646211559.362865
Gr2_im_8_2 0 s8 x2_im_a2 0 -25399818998.613457
Gr3_re_8_2 0 s8 x3_re_a2 0 30419089453.062946
Gr3_im_8_2 0 s8 x3_im_a2 0 62182640576.38598
Gr4_re_8_2 0 s8 x4_re_a2 0 -15315926514.624521
Gr4_im_8_2 0 s8 x4_im_a2 0 -211858253335.5748
Gr5_re_8_2 0 s8 x5_re_a2 0 -11225433900.648247
Gr5_im_8_2 0 s8 x5_im_a2 0 21834907630.511044
Gr6_re_8_2 0 s8 x6_re_a2 0 132482066.56788035
Gr6_im_8_2 0 s8 x6_im_a2 0 301843677.0630564
Gr7_re_8_2 0 s8 x7_re_a2 0 755181098642.2301
Gr7_im_8_2 0 s8 x7_im_a2 0 57843397950.07464
Gr8_8_2 0 s8 x8_a2 0 -1695982115934.3672
Gr9_re_8_2 0 s8 x9_re_a2 0 -112936487313.56108
Gr9_im_8_2 0 s8 x9_im_a2 0 -406930401614.55554
Gr10_8_2 0 s8 x10_a2 0 15080864196.233189
Gr11_re_8_2 0 s8 x11_re_a2 0 -1130874058.761973
Gr11_im_8_2 0 s8 x11_im_a2 0 -227136927.1335871
Gr12_re_8_2 0 s8 x12_re_a2 0 -140772314.28789514
Gr12_im_8_2 0 s8 x12_im_a2 0 -153650330.33157593
Gd8_3 0 s8 p3 0 1.873092398844583e-06
Fd8_3 0 s8 V3 9.365461994222915e-05
Gr1_8_3 0 s8 x1_a3 0 866320819030.7513
Gr2_re_8_3 0 s8 x2_re_a3 0 -49766620949.46757
Gr2_im_8_3 0 s8 x2_im_a3 0 -21223036736.10163
Gr3_re_8_3 0 s8 x3_re_a3 0 258906931286.08533
Gr3_im_8_3 0 s8 x3_im_a3 0 86117724065.07892
Gr4_re_8_3 0 s8 x4_re_a3 0 -326342356859.5699
Gr4_im_8_3 0 s8 x4_im_a3 0 -249394307480.41113
Gr5_re_8_3 0 s8 x5_re_a3 0 -2414508943.2017307
Gr5_im_8_3 0 s8 x5_im_a3 0 18739018973.3399
Gr6_re_8_3 0 s8 x6_re_a3 0 2505998012.2087903
Gr6_im_8_3 0 s8 x6_im_a3 0 1421370169.888676
Gr7_re_8_3 0 s8 x7_re_a3 0 1620983914121.3782
Gr7_im_8_3 0 s8 x7_im_a3 0 46871701742.01516
Gr8_8_3 0 s8 x8_a3 0 -3098488770903.755
Gr9_re_8_3 0 s8 x9_re_a3 0 -248694784002.06735
Gr9_im_8_3 0 s8 x9_im_a3 0 -727383323714.7742
Gr10_8_3 0 s8 x10_a3 0 23301779882.468082
Gr11_re_8_3 0 s8 x11_re_a3 0 -1787303522.5292993
Gr11_im_8_3 0 s8 x11_im_a3 0 -369786266.8734802
Gr12_re_8_3 0 s8 x12_re_a3 0 -227960358.97346893
Gr12_im_8_3 0 s8 x12_im_a3 0 -222320674.45865247
Gd8_4 0 s8 p4 0 -1.4016081950476554e-06
Fd8_4 0 s8 V4 -7.008040975238277e-05
Gr1_8_4 0 s8 x1_a4 0 -1227080303049.5764
Gr2_re_8_4 0 s8 x2_re_a4 0 -18503937930.508247
Gr2_im_8_4 0 s8 x2_im_a4 0 -6830212328.373837
Gr3_re_8_4 0 s8 x3_re_a4 0 -249162851386.742
Gr3_im_8_4 0 s8 x3_im_a4 0 -203919158933.29956
Gr4_re_8_4 0 s8 x4_re_a4 0 323136540232.4641
Gr4_im_8_4 0 s8 x4_im_a4 0 574900133639.9159
Gr5_re_8_4 0 s8 x5_re_a4 0 -68092785294.465485
Gr5_im_8_4 0 s8 x5_im_a4 0 -9271637706.69014
Gr6_re_8_4 0 s8 x6_re_a4 0 -2668324483.860984
Gr6_im_8_4 0 s8 x6_im_a4 0 -1943100093.6581576
Gr7_re_8_4 0 s8 x7_re_a4 0 -2765041681291.0747
Gr7_im_8_4 0 s8 x7_im_a4 0 -102303240710.67323
Gr8_8_4 0 s8 x8_a4 0 5532825472361.279
Gr9_re_8_4 0 s8 x9_re_a4 0 438804116929.0381
Gr9_im_8_4 0 s8 x9_im_a4 0 1393808041749.1086
Gr10_8_4 0 s8 x10_a4 0 -41526339891.33038
Gr11_re_8_4 0 s8 x11_re_a4 0 2984470298.528753
Gr11_im_8_4 0 s8 x11_im_a4 0 511731211.90505755
Gr12_re_8_4 0 s8 x12_re_a4 0 360875327.1631261
Gr12_im_8_4 0 s8 x12_im_a4 0 356017444.51459485
Gd8_5 0 s8 p5 0 4.045078799463919e-07
Fd8_5 0 s8 V5 2.02253939973196e-05
Gr1_8_5 0 s8 x1_a5 0 124597427231.69067
Gr2_re_8_5 0 s8 x2_re_a5 0 -14595919791.207129
Gr2_im_8_5 0 s8 x2_im_a5 0 5851800678.323879
Gr3_re_8_5 0 s8 x3_re_a5 0 -130643403610.826
Gr3_im_8_5 0 s8 x3_im_a5 0 -48863400389.88697
Gr4_re_8_5 0 s8 x4_re_a5 0 -896011665.8420476
Gr4_im_8_5 0 s8 x4_im_a5 0 132525287823.21959
Gr5_re_8_5 0 s8 x5_re_a5 0 -34405442175.94022
Gr5_im_8_5 0 s8 x5_im_a5 0 2997271881.551457
Gr6_re_8_5 0 s8 x6_re_a5 0 -58483454.10504019
Gr6_im_8_5 0 s8 x6_im_a5 0 -214208548.63116336
Gr7_re_8_5 0 s8 x7_re_a5 0 -498658452502.7841
Gr7_im_8_5 0 s8 x7_im_a5 0 -54996077018.77976
Gr8_8_5 0 s8 x8_a5 0 1141210824604.206
Gr9_re_8_5 0 s8 x9_re_a5 0 76209135477.58046
Gr9_im_8_5 0 s8 x9_im_a5 0 265613536603.34155
Gr10_8_5 0 s8 x10_a5 0 -10037536355.921463
Gr11_re_8_5 0 s8 x11_re_a5 0 760249084.935672
Gr11_im_8_5 0 s8 x11_im_a5 0 135112828.18957883
Gr12_re_8_5 0 s8 x12_re_a5 0 93113951.33595859
Gr12_im_8_5 0 s8 x12_im_a5 0 98856820.47839598
Gd8_6 0 s8 p6 0 5.922039790950961e-07
Fd8_6 0 s8 V6 2.9610198954754807e-05
Gr1_8_6 0 s8 x1_a6 0 907840398811.4116
Gr2_re_8_6 0 s8 x2_re_a6 0 -6399822925.573023
Gr2_im_8_6 0 s8 x2_im_a6 0 4233685016.6214824
Gr3_re_8_6 0 s8 x3_re_a6 0 -123823492868.99844
Gr3_im_8_6 0 s8 x3_im_a6 0 -100457202617.16762
Gr4_re_8_6 0 s8 x4_re_a6 0 -27327289918.13066
Gr4_im_8_6 0 s8 x4_im_a6 0 114289196134.13959
Gr5_re_8_6 0 s8 x5_re_a6 0 -34223672708.850872
Gr5_im_8_6 0 s8 x5_im_a6 0 -2370341141.380345
Gr6_re_8_6 0 s8 x6_re_a6 0 -63439211.71312643
Gr6_im_8_6 0 s8 x6_im_a6 0 -221875988.745026
Gr7_re_8_6 0 s8 x7_re_a6 0 -399756006520.4803
Gr7_im_8_6 0 s8 x7_im_a6 0 20290499546.630905
Gr8_8_6 0 s8 x8_a6 0 864595201588.7615
Gr9_re_8_6 0 s8 x9_re_a6 0 62913431209.763084
Gr9_im_8_6 0 s8 x9_im_a6 0 186244914899.89053
Gr10_8_6 0 s8 x10_a6 0 -3237482414.301429
Gr11_re_8_6 0 s8 x11_re_a6 0 111093520.03924659
Gr11_im_8_6 0 s8 x11_im_a6 0 -54839768.86702939
Gr12_re_8_6 0 s8 x12_re_a6 0 3321941.9363706885
Gr12_im_8_6 0 s8 x12_im_a6 0 -2393240.5685038893
Gd8_7 0 s8 p7 0 -1.4327383218148972e-06
Fd8_7 0 s8 V7 -7.163691609074486e-05
Gr1_8_7 0 s8 x1_a7 0 2849986710577.8726
Gr2_re_8_7 0 s8 x2_re_a7 0 -157550573699.40396
Gr2_im_8_7 0 s8 x2_im_a7 0 -211753092762.62326
Gr3_re_8_7 0 s8 x3_re_a7 0 288542937568.0328
Gr3_im_8_7 0 s8 x3_im_a7 0 173876242900.4631
Gr4_re_8_7 0 s8 x4_re_a7 0 -327531159969.1925
Gr4_im_8_7 0 s8 x4_im_a7 0 -495054617108.4012
Gr5_re_8_7 0 s8 x5_re_a7 0 8506062105.322174
Gr5_im_8_7 0 s8 x5_im_a7 0 29302319621.367115
Gr6_re_8_7 0 s8 x6_re_a7 0 2354601123.2182717
Gr6_im_8_7 0 s8 x6_im_a7 0 2736320172.5843105
Gr7_re_8_7 0 s8 x7_re_a7 0 1957974022793.8591
Gr7_im_8_7 0 s8 x7_im_a7 0 4491463257.256597
Gr8_8_7 0 s8 x8_a7 0 -4513995478805.891
Gr9_re_8_7 0 s8 x9_re_a7 0 -306567863404.9569
Gr9_im_8_7 0 s8 x9_im_a7 0 -1251206100994.2173
Gr10_8_7 0 s8 x10_a7 0 38933913381.79882
Gr11_re_8_7 0 s8 x11_re_a7 0 -2708047426.6639977
Gr11_im_8_7 0 s8 x11_im_a7 0 -519493089.70661235
Gr12_re_8_7 0 s8 x12_re_a7 0 -331077268.38926965
Gr12_im_8_7 0 s8 x12_im_a7 0 -376251628.97685516
Gd8_8 0 s8 p8 0 9.644886814785814e-07
Fd8_8 0 s8 V8 4.8224434073929075e-05
Gr1_8_8 0 s8 x1_a8 0 -3391850482174.165
Gr2_re_8_8 0 s8 x2_re_a8 0 234665169010.4569
Gr2_im_8_8 0 s8 x2_im_a8 0 197056001319.94232
Gr3_re_8_8 0 s8 x3_re_a8 0 71267001403.46173
Gr3_im_8_8 0 s8 x3_im_a8 0 -101872847891.8807
Gr4_re_8_8 0 s8 x4_re_a8 0 282099826847.7032
Gr4_im_8_8 0 s8 x4_im_a8 0 73670183086.5078
Gr5_re_8_8 0 s8 x5_re_a8 0 -38507664134.8993
Gr5_im_8_8 0 s8 x5_im_a8 0 678365851.4591177
Gr6_re_8_8 0 s8 x6_re_a8 0 -2104160500.2354248
Gr6_im_8_8 0 s8 x6_im_a8 0 -2122013100.9525943
Gr7_re_8_8 0 s8 x7_re_a8 0 -562518676505.0553
Gr7_im_8_8 0 s8 x7_im_a8 0 83561554467.27225
Gr8_8_8 0 s8 x8_a8 0 1540911527100.4292
Gr9_re_8_8 0 s8 x9_re_a8 0 93868617848.9424
Gr9_im_8_8 0 s8 x9_im_a8 0 440306843537.2776
Gr10_8_8 0 s8 x10_a8 0 -14743672029.984861
Gr11_re_8_8 0 s8 x11_re_a8 0 975982301.8388106
Gr11_im_8_8 0 s8 x11_im_a8 0 205748354.53274745
Gr12_re_8_8 0 s8 x12_re_a8 0 115351547.76680169
Gr12_im_8_8 0 s8 x12_im_a8 0 139478539.70413506
*
* State networks driven by port 8
Cx1_a8 x1_a8 0 1.0
Gx1_a8 0 x1_a8 p8 0 0.07071067811865475
Fx1_a8 0 x1_a8 V8 3.5355339059327378
Rp1_a8 0 x1_a8 9.217407145044509e-14
Cx2_re_a8 x2_re_a8 0 1.0
Gx2_re_a8 0 x2_re_a8 p8 0 0.1414213562373095
Fx2_re_a8 0 x2_re_a8 V8 7.0710678118654755
Rp2_re_re_a8 0 x2_re_a8 1.0786132166118383e-12
Gp2_re_im_a8 0 x2_re_a8 x2_im_a8 0 5111233610923.186
Cx2_im_a8 x2_im_a8 0 1.0
Gp2_im_re_a8 0 x2_im_a8 x2_re_a8 0 -5111233610923.186
Rp2_im_im_a8 0 x2_im_a8 1.0786132166118383e-12
Cx3_re_a8 x3_re_a8 0 1.0
Gx3_re_a8 0 x3_re_a8 p8 0 0.1414213562373095
Fx3_re_a8 0 x3_re_a8 V8 7.0710678118654755
Rp3_re_re_a8 0 x3_re_a8 9.88767760173926e-13
Gp3_re_im_a8 0 x3_re_a8 x3_im_a8 0 3508473312410.142
Cx3_im_a8 x3_im_a8 0 1.0
Gp3_im_re_a8 0 x3_im_a8 x3_re_a8 0 -3508473312410.142
Rp3_im_im_a8 0 x3_im_a8 9.88767760173926e-13
Cx4_re_a8 x4_re_a8 0 1.0
Gx4_re_a8 0 x4_re_a8 p8 0 0.1414213562373095
Fx4_re_a8 0 x4_re_a8 V8 7.0710678118654755
Rp4_re_re_a8 0 x4_re_a8 8.533325723003939e-13
Gp4_re_im_a8 0 x4_re_a8 x4_im_a8 0 2766197540793.715
Cx4_im_a8 x4_im_a8 0 1.0
Gp4_im_re_a8 0 x4_im_a8 x4_re_a8 0 -2766197540793.715
Rp4_im_im_a8 0 x4_im_a8 8.533325723003939e-13
Cx5_re_a8 x5_re_a8 0 1.0
Gx5_re_a8 0 x5_re_a8 p8 0 0.1414213562373095
Fx5_re_a8 0 x5_re_a8 V8 7.0710678118654755
Rp5_re_re_a8 0 x5_re_a8 2.410991705178112e-12
Gp5_re_im_a8 0 x5_re_a8 x5_im_a8 0 2874456996728.0483
Cx5_im_a8 x5_im_a8 0 1.0
Gp5_im_re_a8 0 x5_im_a8 x5_re_a8 0 -2874456996728.0483
Rp5_im_im_a8 0 x5_im_a8 2.410991705178112e-12
Cx6_re_a8 x6_re_a8 0 1.0
Gx6_re_a8 0 x6_re_a8 p8 0 0.1414213562373095
Fx6_re_a8 0 x6_re_a8 V8 7.0710678118654755
Rp6_re_re_a8 0 x6_re_a8 1.6191077353663697e-11
Gp6_re_im_a8 0 x6_re_a8 x6_im_a8 0 2387826528783.5156
Cx6_im_a8 x6_im_a8 0 1.0
Gp6_im_re_a8 0 x6_im_a8 x6_re_a8 0 -2387826528783.5156
Rp6_im_im_a8 0 x6_im_a8 1.6191077353663697e-11
Cx7_re_a8 x7_re_a8 0 1.0
Gx7_re_a8 0 x7_re_a8 p8 0 0.1414213562373095
Fx7_re_a8 0 x7_re_a8 V8 7.0710678118654755
Rp7_re_re_a8 0 x7_re_a8 1.1670965837274465e-12
Gp7_re_im_a8 0 x7_re_a8 x7_im_a8 0 590648106330.5088
Cx7_im_a8 x7_im_a8 0 1.0
Gp7_im_re_a8 0 x7_im_a8 x7_re_a8 0 -590648106330.5088
Rp7_im_im_a8 0 x7_im_a8 1.1670965837274465e-12
Cx8_a8 x8_a8 0 1.0
Gx8_a8 0 x8_a8 p8 0 0.07071067811865475
Fx8_a8 0 x8_a8 V8 3.5355339059327378
Rp8_a8 0 x8_a8 1.057099515142882e-12
Cx9_re_a8 x9_re_a8 0 1.0
Gx9_re_a8 0 x9_re_a8 p8 0 0.1414213562373095
Fx9_re_a8 0 x9_re_a8 V8 7.0710678118654755
Rp9_re_re_a8 0 x9_re_a8 1.5534303609826191e-12
Gp9_re_im_a8 0 x9_re_a8 x9_im_a8 0 455649394468.80255
Cx9_im_a8 x9_im_a8 0 1.0
Gp9_im_re_a8 0 x9_im_a8 x9_re_a8 0 -455649394468.80255
Rp9_im_im_a8 0 x9_im_a8 1.5534303609826191e-12
Cx10_a8 x10_a8 0 1.0
Gx10_a8 0 x10_a8 p8 0 0.07071067811865475
Fx10_a8 0 x10_a8 V8 3.5355339059327378
Rp10_a8 0 x10_a8 5.21381713713202e-12
Cx11_re_a8 x11_re_a8 0 1.0
Gx11_re_a8 0 x11_re_a8 p8 0 0.1414213562373095
Fx11_re_a8 0 x11_re_a8 V8 7.0710678118654755
Rp11_re_re_a8 0 x11_re_a8 1.673721870740383e-11
Gp11_re_im_a8 0 x11_re_a8 x11_im_a8 0 51505589949.64772
Cx11_im_a8 x11_im_a8 0 1.0
Gp11_im_re_a8 0 x11_im_a8 x11_re_a8 0 -51505589949.64772
Rp11_im_im_a8 0 x11_im_a8 1.673721870740383e-11
Cx12_re_a8 x12_re_a8 0 1.0
Gx12_re_a8 0 x12_re_a8 p8 0 0.1414213562373095
Fx12_re_a8 0 x12_re_a8 V8 7.0710678118654755
Rp12_re_re_a8 0 x12_re_a8 6.344273526229328e-11
Gp12_re_im_a8 0 x12_re_a8 x12_im_a8 0 6300408112.88573
Cx12_im_a8 x12_im_a8 0 1.0
Gp12_im_re_a8 0 x12_im_a8 x12_re_a8 0 -6300408112.88573
Rp12_im_im_a8 0 x12_im_a8 6.344273526229328e-11
.ENDS Trafo_LO

.SUBCKT IHP_PDK_basic_components_ptap1  gnd P1 P2 w=0.78e-6 l=0.78e-6
X1 P1 P2 ptap1 w={w} l={l}
.ENDS

.PARAM MLO = 50p
.PARAM LsLO = 30p
.PARAM LpLO = 20p
.PARAM CsLO = 5f
.PARAM M = 220p
.PARAM Ls = 850p
.PARAM Lp = 250p
.PARAM Cs = 10f
Xnpn13G1 0 v_coll RF_M_p _net0 sub IHP_PDK_nonlinear_components_npn13G2 Nx=4
Xnpn13G2 0 Vcoll2 RF_M_n _net1 sub IHP_PDK_nonlinear_components_npn13G2 Nx=4
Xnpn13G3 0 IF_M_p LO_M_p v_coll sub IHP_PDK_nonlinear_components_npn13G2 Nx=3
Xnpn13G4 0 IF_M_n LO_M_n v_coll sub IHP_PDK_nonlinear_components_npn13G2 Nx=3
Xnpn13G5 0 IF_M_p LO_M_n Vcoll2 sub IHP_PDK_nonlinear_components_npn13G2 Nx=3
Xnpn13G6 0 IF_M_n LO_M_p Vcoll2 sub IHP_PDK_nonlinear_components_npn13G2 Nx=3
R1 0 _net2  10 tc1=0.0 tc2=0.0
R2 _net2 _net0  100 tc1=0.0 tc2=0.0
R3 _net2 _net1  100 tc1=0.0 tc2=0.0
XSUB1 _net3 _net4 _net5 _net6 0 ideal_balun
XSUB2 _net7 IF_COM IF_neg IF_pos 0 ideal_balun
XSUB3 _net8 _net9 _net10 _net11 0 ideal_balun
C1 0 _net12  300F
C2 0 _net13  300F

X3 _net14 _net15 _net16 _net17 _net12 _net18 RF_neg RF_pos s_equivalent90
X4 _net19 _net13 LO_neg LO_pos _net20 _net21 LO_M_n LO_M_p Trafo_LO
VOut Out _net22 DC 0
P3 _net22 0 port=3  z0=100  AC 0.89442719  SIN 0 0.89442719 0
LM_neg1 _net23 Vdd2  {M}
LM_pos1 Vdd2 _net24  {M}
Ls_pos1 IF_M_p _net24  {LS}
Ls_neg1 IF_M_n _net23  {LS}
Lp_pos1 _net24 _net25  {LP}
Lp_neg1 _net23 _net26  {LP}
Cshunt_pos1 _net25 0  {CS}
Cshunt_neg1 0 _net26  {CS}
C5 _net7 Out 1U
C4 _net8 LO_in 1U
C3 RF_in _net3 1U
V5 Vdd 0 DC 2.5
V6 VdcRF 0 DC 1.254

Xptap1 0 sub 0 IHP_PDK_basic_components_ptap1 w=0.78U l=0.78U
V7 Vdd2 0 DC 2.5
R9 0 RF_CM  25 tc1=0.0 tc2=0.0
R7 LO_CM 0  25 tc1=0.0 tc2=0.0
R8 _net27 0  25 tc1=0.0 tc2=0.0
VRF_pos _net6 RF_pos DC 0
VRF_neg _net5 RF_neg DC 0
VRF_M_n _net16 RF_M_n DC 0
VRF_M_p _net17 RF_M_p DC 0
VIF_pos _net25 IF_pos DC 0
VIF_neg _net26 IF_neg DC 0
VRF_IN _net28 RF_in DC 0
VLO_IN _net29 LO_in DC 0
VLO_pos _net11 LO_pos DC 0
VLO_neg _net10 LO_neg DC 0
VRF_CM _net4 RF_CM DC 0
VLO_CM _net9 LO_CM DC 0
VIF_CM IF_COM _net27 DC 0
LM_pos9 Vdd LO_M_n  1
LM_pos10 Vdd LO_M_p  1
LM_pos7 _net17 VdcRF  1
LM_pos8 _net16 VdcRF  1
P1 _net29 0 port=2  z0=100  AC 0.28284271  SIN 0 0.28284271 95G
P2 _net28 0 port=1  z0=100  AC 0.089442719  SIN 0 0.089442719 130G
.tran 1.001e-12 1e-09 0 1.001e-12
.PRINT  tran format=raw file=spice4qucs.tran.plot I(VIF_CM) I(VIF_neg) I(VIF_pos) I(VLO_CM) I(VLO_IN) I(VLO_neg) I(VLO_pos) I(VOut) I(VRF_CM) I(VRF_IN) I(VRF_M_n) I(VRF_M_p) I(VRF_neg) I(VRF_pos) v(IF_COM) v(IF_M_n) v(IF_M_p) v(IF_neg) v(IF_pos) v(LO_CM) v(LO_M_n) v(LO_M_p) v(LO_in) v(LO_neg) v(LO_pos) v(Out) v(RF_CM) v(RF_M_n) v(RF_M_p) v(RF_in) v(RF_neg) v(RF_pos) v(Vcoll2) v(VdcRF) v(Vdd) v(Vdd2) v(sub) v(v_coll)
.END
