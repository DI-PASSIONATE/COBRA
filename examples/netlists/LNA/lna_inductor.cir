* Qucs 26.1.0  /home/users/simone/Hiwi/HB_example_LNA.sch
* COBRA preset: 130 GHz cascode LNA with an ORCA octagonal-inductor surrogate (XYLIN_X1).
* Optimized with examples/configs/lna_inductor_config.json (Xyce, 300 trials). The values
* below are the optimum; the inductor geometry is an input of its ONNX model, not part of
* this netlist: turns=2, width=10.5, space=3, diameter=229 (um).
* Result: S11 -12.2..-11.9 dB, S22 -14.0..-9.1 dB, S21 6.7..7.8 dB (125-135 GHz),
* NF 4.79 dB at 130 GHz; unconditionally stable 110-170 GHz (K >= 5.7, mu >= 1.49).
* Testbench change from the Qucs-S original: the 50 Ohm output load R4 is the port P2.
.LIB "/home/david/Documents/git/IHP-Open-PDK/ihp-sg13g2/libs.tech/xyce/models/cornerRES.lib" res_typ
.LIB "/home/david/Documents/git/IHP-Open-PDK/ihp-sg13g2/libs.tech/xyce/models/cornerHBT.lib" hbt_typ
.LIB "/home/david/Documents/git/IHP-Open-PDK/ihp-sg13g2/libs.tech/xyce/models/cornerCAP.lib" cap_typ

.SUBCKT IHP_PDK_nonlinear_components_npn13G2  gnd c b e bn Nx=1
X1 c b e bn npn13G2 Nx={Nx}
.ENDS

.SUBCKT IHP_PDK_basic_components_ptap1  gnd P1 P2 w=0.78e-6 l=0.78e-6
X1 P1 P2 ptap1 w={w} l={l}
.ENDS

.PARAM Cout = 44f
V1 Vdd 0 DC 2.5
L1 _net0 _net1  42P
L2 _net2 _net1  30P
Xnpn13G1 0 _net0 _net0 0 sub IHP_PDK_nonlinear_components_npn13G2 Nx=1
R1 _net3 Vdd  3K tc1=0.0 tc2=0.0
R2 0 _net3  13K tc1=0.0 tc2=0.0
R3 _net0 Vdd  2.5K tc1=0.0 tc2=0.0
C2 0 _net0  200F
C3 0 _net2  21F
C4 _net4 _net2  315F
C5 0 _net3  72F
Xnpn13G2 0 _net5 _net1 0 sub IHP_PDK_nonlinear_components_npn13G2 Nx=9
Xnpn13G3 0 ip _net3 _net5 sub IHP_PDK_nonlinear_components_npn13G2 Nx=5
Xptap1 0 sub 0 IHP_PDK_basic_components_ptap1 w=0.78U l=0.78U

VOut Out _net6 DC 0
L4 Vdd ip  10N
C6 0 Out  5F
P2 _net6 0 port=2 z0=50
P1 _net4 0 port=1  z0=50  AC 0.2  SIN 0 0.2 130G
YLIN YLIN_X1 ip 0 Out 0 _net7 0 YLIN_X1_model
.MODEL YLIN_X1_model LIN TSTONEFILE=inductor.s3p
.AC LIN 1000 110G 170G
.LIN format=touchstone sparcalc=1
.PRINT ac format=std file=spice4qucs_sparam.prn sdb(1,1) s(1,1) sp(1,1) y(1,1) z(1,1)
.END
