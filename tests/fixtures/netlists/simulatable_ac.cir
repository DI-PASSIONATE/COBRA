* Self-contained 2-port network with no dangling references: every subcircuit is
* defined inline and there are no .INCLUDE, .LIB or Touchstone dependencies.
.SUBCKT lowpass lp_in lp_out
RLP lp_in lp_out 50
CLP lp_out 0 1p
.ENDS
P1 in 0 port=1 z0=50 AC 1
P2 out 0 port=2 z0=50
R1 in n1 25
C1 n1 0 100f
L1 n1 out 1n
X1 n1 out lowpass
.AC LIN 11 1G 10G
.LIN format=touchstone
.END
